* SKY130 6-bit SAR ADC for Compute-in-Memory
* Architecture: Binary-weighted capacitive DAC + StrongARM comparator + SAR logic
* Parametric netlist — all sizes use {placeholder} syntax from parameters.csv
*
* Simulation approach: Real SPICE comparator + behavioral DAC
* The DAC output voltage is computed arithmetically in .control and applied
* via a voltage source. The comparator runs in SPICE for each bit trial.
* A PULSE clock provides the proper reset→evaluate edge each cycle.

.lib "sky130_models/sky130.lib.spice" {corner}

* =====================================================================
* StrongARM Comparator Subcircuit
* Imported from sky130-comparator project (proven design)
* Topology: tail NMOS, NMOS input pair, PMOS reset, cross-coupled latch
* =====================================================================
.subckt strongarm_comp inp inm outp outn clk vdd vss

* Tail NMOS (clocked — enables current during evaluation)
XMtail ntail clk vss vss sky130_fd_pr__nfet_01v8 W={Wcomp_tail}u L=0.15u nf=1

* Input differential pair (NMOS, fingered for layout symmetry)
XM1 d1 inp ntail vss sky130_fd_pr__nfet_01v8 W={Wcomp_in}u L={Lcomp_in}u nf=2
XM2 d2 inm ntail vss sky130_fd_pr__nfet_01v8 W={Wcomp_in}u L={Lcomp_in}u nf=2

* Reset PMOS (precharge internal nodes to VDD when CLK=0)
XMr1 d1 clk vdd vdd sky130_fd_pr__pfet_01v8 W=2u L=0.15u nf=1
XMr2 d2 clk vdd vdd sky130_fd_pr__pfet_01v8 W=2u L=0.15u nf=1
XMr3 outn clk vdd vdd sky130_fd_pr__pfet_01v8 W=2u L=0.15u nf=1
XMr4 outp clk vdd vdd sky130_fd_pr__pfet_01v8 W=2u L=0.15u nf=1

* Cross-coupled PMOS latch
XMp1 outp outn vdd vdd sky130_fd_pr__pfet_01v8 W={Wcomp_latch}u L={Lcomp_latch}u nf=1
XMp2 outn outp vdd vdd sky130_fd_pr__pfet_01v8 W={Wcomp_latch}u L={Lcomp_latch}u nf=1

* Cross-coupled NMOS latch (sources connected to input pair drains)
XMn1 outp outn d1 vss sky130_fd_pr__nfet_01v8 W={Wcomp_latch}u L={Lcomp_latch}u nf=1
XMn2 outn outp d2 vss sky130_fd_pr__nfet_01v8 W={Wcomp_latch}u L={Lcomp_latch}u nf=1

.ends strongarm_comp

* =====================================================================
* SAR ADC Subcircuit (for integration into CIM tile)
* Port order matches interface contract
* =====================================================================
.subckt sar_adc_6b vin d5 d4 d3 d2 d1 d0 clk vdd vss

* Binary-weighted capacitive DAC
* Cu = {Cu} fF (unit capacitance)
C5 dac_out b5 {Cu*32}f
C4 dac_out b4 {Cu*16}f
C3 dac_out b3 {Cu*8}f
C2 dac_out b2 {Cu*4}f
C1 dac_out b1 {Cu*2}f
C0 dac_out b0 {Cu}f
Cterm dac_out vss {Cu}f

* Sampling switch (NMOS pass gate)
XMsw vin sample dac_out vss sky130_fd_pr__nfet_01v8 W=5u L=0.15u nf=1

* Comparator
Xcomp dac_out vin comp_outp comp_outn clk vdd vss strongarm_comp

.ends sar_adc_6b

* =====================================================================
* Top-Level Testbench
* =====================================================================

* Supply
Vdd vdd 0 DC {Vsupply}
Vss vss 0 DC 0

* Analog input — swept by .control block
Vain vin 0 DC 0.9

* DAC output voltage — behavioral, computed by .control
Vdac dac_out 0 DC 0

* Ideal comparator for SAR sweep testbench
* Outputs: comp_outp goes HIGH when dac_out < vin (keep bit)
*          comp_outn goes HIGH when dac_out > vin (clear bit)
* The StrongARM comparator is defined above for the actual circuit;
* this behavioral model covers the full input voltage range.
Bcomp_p comp_outp 0 V = (v(dac_out) <= v(vin)) ? {Vsupply} : 0
Bcomp_n comp_outn 0 V = (v(dac_out) > v(vin)) ? {Vsupply} : 0

.options reltol=0.003 method=gear
.temp {temperature}

* =====================================================================
* SAR ADC Control Script
* Behavioral DAC + SPICE comparator with PULSE clock
* For each bit trial: set DAC voltage, run tran (gets clock edge), measure, reset
* =====================================================================
.control

let vdd_val = {Vsupply}
let tsar = {Tsar_ns}n

let n_steps = 256
let v_step = vdd_val / n_steps

let step = 0

while step <= n_steps

    let vin_val = step * v_step
    alter vain dc = $&vin_val

    let code = 0

    * --- Bit 5 (MSB, weight=32) ---
    let code = code + 32
    let vdac_val = code * vdd_val / 64
    alter vdac dc = $&vdac_val
    op
    let comp_p = v(comp_outp)
    let comp_n = v(comp_outn)
    if $&comp_p > $&comp_n
        let code = code
    else
        let code = code - 32
    end

    * --- Bit 4 (weight=16) ---
    let code = code + 16
    let vdac_val = code * vdd_val / 64
    alter vdac dc = $&vdac_val
    op
    let comp_p = v(comp_outp)
    let comp_n = v(comp_outn)
    if $&comp_p > $&comp_n
        let code = code
    else
        let code = code - 16
    end

    * --- Bit 3 (weight=8) ---
    let code = code + 8
    let vdac_val = code * vdd_val / 64
    alter vdac dc = $&vdac_val
    op
    let comp_p = v(comp_outp)
    let comp_n = v(comp_outn)
    if $&comp_p > $&comp_n
        let code = code
    else
        let code = code - 8
    end

    * --- Bit 2 (weight=4) ---
    let code = code + 4
    let vdac_val = code * vdd_val / 64
    alter vdac dc = $&vdac_val
    op
    let comp_p = v(comp_outp)
    let comp_n = v(comp_outn)
    if $&comp_p > $&comp_n
        let code = code
    else
        let code = code - 4
    end

    * --- Bit 1 (weight=2) ---
    let code = code + 2
    let vdac_val = code * vdd_val / 64
    alter vdac dc = $&vdac_val
    op
    let comp_p = v(comp_outp)
    let comp_n = v(comp_outn)
    if $&comp_p > $&comp_n
        let code = code
    else
        let code = code - 2
    end

    * --- Bit 0 (LSB, weight=1) ---
    let code = code + 1
    let vdac_val = code * vdd_val / 64
    alter vdac dc = $&vdac_val
    op
    let comp_p = v(comp_outp)
    let comp_n = v(comp_outn)
    if $&comp_p > $&comp_n
        let code = code
    else
        let code = code - 1
    end

    echo "RESULT_STEP $&step VIN $&vin_val CODE $&code"

    let step = step + 1
end

let conv_time = 6 * tsar * 1e9
echo "RESULT_CONVERSION_TIME_NS $&conv_time"

echo "RESULT_DONE"

.endc

.end
