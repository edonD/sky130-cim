* CIM Array 64x8 -- Auto-generated by evaluate.py
.lib "sky130_models/sky130.lib.spice" sf
.param supply=1.8

.subckt cim_bitcell bl blb wl wwl q qb vdd vss
* 6T SRAM storage core
XPL q qb vdd vdd sky130_fd_pr__pfet_01v8 w=0.55u l=0.15u
XPR qb q vdd vdd sky130_fd_pr__pfet_01v8 w=0.55u l=0.15u
XNL q qb vss vss sky130_fd_pr__nfet_01v8 w=0.84u l=0.15u
XNR qb q vss vss sky130_fd_pr__nfet_01v8 w=0.84u l=0.15u
* Write access transistors
XAXL blb wwl q vss sky130_fd_pr__nfet_01v8 w=0.42u l=0.15u
XAXR bl wwl qb vss sky130_fd_pr__nfet_01v8 w=0.42u l=0.15u
* 2T decoupled read port: BL -> RD1 (gate=Q) -> mid -> RD2 (gate=WL) -> VSS
XRD1 bl q mid vss sky130_fd_pr__nfet_01v8 w=0.42u l=1.0u
XRD2 mid wl vss vss sky130_fd_pr__nfet_01v8 w=0.42u l=1.0u
.ends cim_bitcell

* Precharge circuit
.subckt precharge bl pre vdd vss
XPRE vdd pre bl vdd sky130_fd_pr__pfet_01v8 w=10.0u l=0.15u
.ends precharge

Vdd vdd 0 {supply}
Vss vss 0 0

* Precharge: low (PMOS on) for 20.0ns, then high (PMOS off) for compute
Vpre pre 0 PWL(0 0 20.0n 0 20.1n 1.8)

Xpre0 bl0 pre vdd vss precharge
Xpre1 bl1 pre vdd vss precharge
Xpre2 bl2 pre vdd vss precharge
Xpre3 bl3 pre vdd vss precharge
Xpre4 bl4 pre vdd vss precharge
Xpre5 bl5 pre vdd vss precharge
Xpre6 bl6 pre vdd vss precharge
Xpre7 bl7 pre vdd vss precharge

Cbl0 bl0 0 177.34375f
Cbl1 bl1 0 177.34375f
Cbl2 bl2 0 177.34375f
Cbl3 bl3 0 177.34375f
Cbl4 bl4 0 177.34375f
Cbl5 bl5 0 177.34375f
Cbl6 bl6 0 177.34375f
Cbl7 bl7 0 177.34375f

* Wordline signals (PWM-encoded inputs)
Vwl0 wl0 0 PWL(0 0 21.0n 0 21.15n 1.8 25.998n 1.8 26.148n 0)
Vwl1 wl1 0 PWL(0 0 21.0n 0 21.15n 1.8 95.97n 1.8 96.12n 0)
Vwl2 wl2 0 PWL(0 0 21.0n 0 21.15n 1.8 80.976n 1.8 81.126n 0)
Vwl3 wl3 0 PWL(0 0 21.0n 0 21.15n 1.8 90.97200000000001n 1.8 91.12200000000001n 0)
Vwl4 wl4 0 PWL(0 0 21.0n 0 21.15n 1.8 35.994n 1.8 36.144n 0)
Vwl5 wl5 0 PWL(0 0 21.0n 0 21.15n 1.8 95.97n 1.8 96.12n 0)
Vwl6 wl6 0 PWL(0 0 21.0n 0 21.15n 1.8 90.97200000000001n 1.8 91.12200000000001n 0)
Vwl7 wl7 0 PWL(0 0 21.0n 0 21.15n 1.8 45.99n 1.8 46.14n 0)
Vwl8 wl8 0 PWL(0 0 21.0n 0 21.15n 1.8 75.97800000000001n 1.8 76.12800000000001n 0)
Vwl9 wl9 0 PWL(0 0 21.0n 0 21.15n 1.8 60.984n 1.8 61.134n 0)
Vwl10 wl10 0 PWL(0 0 21.0n 0 21.15n 1.8 40.992000000000004n 1.8 41.142n 0)
Vwl11 wl11 0 PWL(0 0 21.0n 0 21.15n 1.8 30.996000000000002n 1.8 31.146n 0)
Vwl12 wl12 0 PWL(0 0 21.0n 0 21.15n 1.8 60.984n 1.8 61.134n 0)
Vwl13 wl13 0 PWL(0 0 21.0n 0 21.15n 1.8 65.982n 1.8 66.132n 0)
Vwl14 wl14 0 PWL(0 0 21.0n 0 21.15n 1.8 35.994n 1.8 36.144n 0)
Vwl15 wl15 0 PWL(0 0 21.0n 0 21.15n 1.8 70.98n 1.8 71.13000000000001n 0)
Vwl16 wl16 0 PWL(0 0 21.0n 0 21.15n 1.8 50.988n 1.8 51.138n 0)
Vwl17 wl17 0 PWL(0 0 21.0n 0 21.15n 1.8 30.996000000000002n 1.8 31.146n 0)
Vwl18 wl18 0 PWL(0 0 21.0n 0 21.15n 1.8 65.982n 1.8 66.132n 0)
Vwl19 wl19 0 PWL(0 0 21.0n 0 21.15n 1.8 60.984n 1.8 61.134n 0)
Vwl20 wl20 0 0
Vwl21 wl21 0 PWL(0 0 21.0n 0 21.15n 1.8 45.99n 1.8 46.14n 0)
Vwl22 wl22 0 0
Vwl23 wl23 0 PWL(0 0 21.0n 0 21.15n 1.8 55.986000000000004n 1.8 56.136n 0)
Vwl24 wl24 0 PWL(0 0 21.0n 0 21.15n 1.8 25.998n 1.8 26.148n 0)
Vwl25 wl25 0 PWL(0 0 21.0n 0 21.15n 1.8 50.988n 1.8 51.138n 0)
Vwl26 wl26 0 PWL(0 0 21.0n 0 21.15n 1.8 25.998n 1.8 26.148n 0)
Vwl27 wl27 0 PWL(0 0 21.0n 0 21.15n 1.8 95.97n 1.8 96.12n 0)
Vwl28 wl28 0 PWL(0 0 21.0n 0 21.15n 1.8 90.97200000000001n 1.8 91.12200000000001n 0)
Vwl29 wl29 0 PWL(0 0 21.0n 0 21.15n 1.8 50.988n 1.8 51.138n 0)
Vwl30 wl30 0 PWL(0 0 21.0n 0 21.15n 1.8 80.976n 1.8 81.126n 0)
Vwl31 wl31 0 PWL(0 0 21.0n 0 21.15n 1.8 60.984n 1.8 61.134n 0)
Vwl32 wl32 0 0
Vwl33 wl33 0 PWL(0 0 21.0n 0 21.15n 1.8 60.984n 1.8 61.134n 0)
Vwl34 wl34 0 PWL(0 0 21.0n 0 21.15n 1.8 55.986000000000004n 1.8 56.136n 0)
Vwl35 wl35 0 PWL(0 0 21.0n 0 21.15n 1.8 75.97800000000001n 1.8 76.12800000000001n 0)
Vwl36 wl36 0 PWL(0 0 21.0n 0 21.15n 1.8 75.97800000000001n 1.8 76.12800000000001n 0)
Vwl37 wl37 0 0
Vwl38 wl38 0 0
Vwl39 wl39 0 PWL(0 0 21.0n 0 21.15n 1.8 60.984n 1.8 61.134n 0)
Vwl40 wl40 0 PWL(0 0 21.0n 0 21.15n 1.8 70.98n 1.8 71.13000000000001n 0)
Vwl41 wl41 0 PWL(0 0 21.0n 0 21.15n 1.8 30.996000000000002n 1.8 31.146n 0)
Vwl42 wl42 0 PWL(0 0 21.0n 0 21.15n 1.8 45.99n 1.8 46.14n 0)
Vwl43 wl43 0 PWL(0 0 21.0n 0 21.15n 1.8 60.984n 1.8 61.134n 0)
Vwl44 wl44 0 PWL(0 0 21.0n 0 21.15n 1.8 65.982n 1.8 66.132n 0)
Vwl45 wl45 0 PWL(0 0 21.0n 0 21.15n 1.8 60.984n 1.8 61.134n 0)
Vwl46 wl46 0 PWL(0 0 21.0n 0 21.15n 1.8 40.992000000000004n 1.8 41.142n 0)
Vwl47 wl47 0 PWL(0 0 21.0n 0 21.15n 1.8 70.98n 1.8 71.13000000000001n 0)
Vwl48 wl48 0 PWL(0 0 21.0n 0 21.15n 1.8 35.994n 1.8 36.144n 0)
Vwl49 wl49 0 PWL(0 0 21.0n 0 21.15n 1.8 75.97800000000001n 1.8 76.12800000000001n 0)
Vwl50 wl50 0 PWL(0 0 21.0n 0 21.15n 1.8 50.988n 1.8 51.138n 0)
Vwl51 wl51 0 PWL(0 0 21.0n 0 21.15n 1.8 25.998n 1.8 26.148n 0)
Vwl52 wl52 0 PWL(0 0 21.0n 0 21.15n 1.8 90.97200000000001n 1.8 91.12200000000001n 0)
Vwl53 wl53 0 PWL(0 0 21.0n 0 21.15n 1.8 45.99n 1.8 46.14n 0)
Vwl54 wl54 0 0
Vwl55 wl55 0 PWL(0 0 21.0n 0 21.15n 1.8 60.984n 1.8 61.134n 0)
Vwl56 wl56 0 PWL(0 0 21.0n 0 21.15n 1.8 40.992000000000004n 1.8 41.142n 0)
Vwl57 wl57 0 PWL(0 0 21.0n 0 21.15n 1.8 90.97200000000001n 1.8 91.12200000000001n 0)
Vwl58 wl58 0 PWL(0 0 21.0n 0 21.15n 1.8 95.97n 1.8 96.12n 0)
Vwl59 wl59 0 PWL(0 0 21.0n 0 21.15n 1.8 75.97800000000001n 1.8 76.12800000000001n 0)
Vwl60 wl60 0 PWL(0 0 21.0n 0 21.15n 1.8 95.97n 1.8 96.12n 0)
Vwl61 wl61 0 PWL(0 0 21.0n 0 21.15n 1.8 30.996000000000002n 1.8 31.146n 0)
Vwl62 wl62 0 PWL(0 0 21.0n 0 21.15n 1.8 30.996000000000002n 1.8 31.146n 0)
Vwl63 wl63 0 PWL(0 0 21.0n 0 21.15n 1.8 30.996000000000002n 1.8 31.146n 0)

Vwwl0 wwl0 0 0
Vwwl1 wwl1 0 0
Vwwl2 wwl2 0 0
Vwwl3 wwl3 0 0
Vwwl4 wwl4 0 0
Vwwl5 wwl5 0 0
Vwwl6 wwl6 0 0
Vwwl7 wwl7 0 0
Vwwl8 wwl8 0 0
Vwwl9 wwl9 0 0
Vwwl10 wwl10 0 0
Vwwl11 wwl11 0 0
Vwwl12 wwl12 0 0
Vwwl13 wwl13 0 0
Vwwl14 wwl14 0 0
Vwwl15 wwl15 0 0
Vwwl16 wwl16 0 0
Vwwl17 wwl17 0 0
Vwwl18 wwl18 0 0
Vwwl19 wwl19 0 0
Vwwl20 wwl20 0 0
Vwwl21 wwl21 0 0
Vwwl22 wwl22 0 0
Vwwl23 wwl23 0 0
Vwwl24 wwl24 0 0
Vwwl25 wwl25 0 0
Vwwl26 wwl26 0 0
Vwwl27 wwl27 0 0
Vwwl28 wwl28 0 0
Vwwl29 wwl29 0 0
Vwwl30 wwl30 0 0
Vwwl31 wwl31 0 0
Vwwl32 wwl32 0 0
Vwwl33 wwl33 0 0
Vwwl34 wwl34 0 0
Vwwl35 wwl35 0 0
Vwwl36 wwl36 0 0
Vwwl37 wwl37 0 0
Vwwl38 wwl38 0 0
Vwwl39 wwl39 0 0
Vwwl40 wwl40 0 0
Vwwl41 wwl41 0 0
Vwwl42 wwl42 0 0
Vwwl43 wwl43 0 0
Vwwl44 wwl44 0 0
Vwwl45 wwl45 0 0
Vwwl46 wwl46 0 0
Vwwl47 wwl47 0 0
Vwwl48 wwl48 0 0
Vwwl49 wwl49 0 0
Vwwl50 wwl50 0 0
Vwwl51 wwl51 0 0
Vwwl52 wwl52 0 0
Vwwl53 wwl53 0 0
Vwwl54 wwl54 0 0
Vwwl55 wwl55 0 0
Vwwl56 wwl56 0 0
Vwwl57 wwl57 0 0
Vwwl58 wwl58 0 0
Vwwl59 wwl59 0 0
Vwwl60 wwl60 0 0
Vwwl61 wwl61 0 0
Vwwl62 wwl62 0 0
Vwwl63 wwl63 0 0

* 64x8 bitcell array
Xcell_r0_c0 bl0 blb0 wl0 wwl0 q_r0c0 qb_r0c0 vdd vss cim_bitcell
Xcell_r0_c1 bl1 blb1 wl0 wwl0 q_r0c1 qb_r0c1 vdd vss cim_bitcell
Xcell_r0_c2 bl2 blb2 wl0 wwl0 q_r0c2 qb_r0c2 vdd vss cim_bitcell
Xcell_r0_c3 bl3 blb3 wl0 wwl0 q_r0c3 qb_r0c3 vdd vss cim_bitcell
Xcell_r0_c4 bl4 blb4 wl0 wwl0 q_r0c4 qb_r0c4 vdd vss cim_bitcell
Xcell_r0_c5 bl5 blb5 wl0 wwl0 q_r0c5 qb_r0c5 vdd vss cim_bitcell
Xcell_r0_c6 bl6 blb6 wl0 wwl0 q_r0c6 qb_r0c6 vdd vss cim_bitcell
Xcell_r0_c7 bl7 blb7 wl0 wwl0 q_r0c7 qb_r0c7 vdd vss cim_bitcell
Xcell_r1_c0 bl0 blb0 wl1 wwl1 q_r1c0 qb_r1c0 vdd vss cim_bitcell
Xcell_r1_c1 bl1 blb1 wl1 wwl1 q_r1c1 qb_r1c1 vdd vss cim_bitcell
Xcell_r1_c2 bl2 blb2 wl1 wwl1 q_r1c2 qb_r1c2 vdd vss cim_bitcell
Xcell_r1_c3 bl3 blb3 wl1 wwl1 q_r1c3 qb_r1c3 vdd vss cim_bitcell
Xcell_r1_c4 bl4 blb4 wl1 wwl1 q_r1c4 qb_r1c4 vdd vss cim_bitcell
Xcell_r1_c5 bl5 blb5 wl1 wwl1 q_r1c5 qb_r1c5 vdd vss cim_bitcell
Xcell_r1_c6 bl6 blb6 wl1 wwl1 q_r1c6 qb_r1c6 vdd vss cim_bitcell
Xcell_r1_c7 bl7 blb7 wl1 wwl1 q_r1c7 qb_r1c7 vdd vss cim_bitcell
Xcell_r2_c0 bl0 blb0 wl2 wwl2 q_r2c0 qb_r2c0 vdd vss cim_bitcell
Xcell_r2_c1 bl1 blb1 wl2 wwl2 q_r2c1 qb_r2c1 vdd vss cim_bitcell
Xcell_r2_c2 bl2 blb2 wl2 wwl2 q_r2c2 qb_r2c2 vdd vss cim_bitcell
Xcell_r2_c3 bl3 blb3 wl2 wwl2 q_r2c3 qb_r2c3 vdd vss cim_bitcell
Xcell_r2_c4 bl4 blb4 wl2 wwl2 q_r2c4 qb_r2c4 vdd vss cim_bitcell
Xcell_r2_c5 bl5 blb5 wl2 wwl2 q_r2c5 qb_r2c5 vdd vss cim_bitcell
Xcell_r2_c6 bl6 blb6 wl2 wwl2 q_r2c6 qb_r2c6 vdd vss cim_bitcell
Xcell_r2_c7 bl7 blb7 wl2 wwl2 q_r2c7 qb_r2c7 vdd vss cim_bitcell
Xcell_r3_c0 bl0 blb0 wl3 wwl3 q_r3c0 qb_r3c0 vdd vss cim_bitcell
Xcell_r3_c1 bl1 blb1 wl3 wwl3 q_r3c1 qb_r3c1 vdd vss cim_bitcell
Xcell_r3_c2 bl2 blb2 wl3 wwl3 q_r3c2 qb_r3c2 vdd vss cim_bitcell
Xcell_r3_c3 bl3 blb3 wl3 wwl3 q_r3c3 qb_r3c3 vdd vss cim_bitcell
Xcell_r3_c4 bl4 blb4 wl3 wwl3 q_r3c4 qb_r3c4 vdd vss cim_bitcell
Xcell_r3_c5 bl5 blb5 wl3 wwl3 q_r3c5 qb_r3c5 vdd vss cim_bitcell
Xcell_r3_c6 bl6 blb6 wl3 wwl3 q_r3c6 qb_r3c6 vdd vss cim_bitcell
Xcell_r3_c7 bl7 blb7 wl3 wwl3 q_r3c7 qb_r3c7 vdd vss cim_bitcell
Xcell_r4_c0 bl0 blb0 wl4 wwl4 q_r4c0 qb_r4c0 vdd vss cim_bitcell
Xcell_r4_c1 bl1 blb1 wl4 wwl4 q_r4c1 qb_r4c1 vdd vss cim_bitcell
Xcell_r4_c2 bl2 blb2 wl4 wwl4 q_r4c2 qb_r4c2 vdd vss cim_bitcell
Xcell_r4_c3 bl3 blb3 wl4 wwl4 q_r4c3 qb_r4c3 vdd vss cim_bitcell
Xcell_r4_c4 bl4 blb4 wl4 wwl4 q_r4c4 qb_r4c4 vdd vss cim_bitcell
Xcell_r4_c5 bl5 blb5 wl4 wwl4 q_r4c5 qb_r4c5 vdd vss cim_bitcell
Xcell_r4_c6 bl6 blb6 wl4 wwl4 q_r4c6 qb_r4c6 vdd vss cim_bitcell
Xcell_r4_c7 bl7 blb7 wl4 wwl4 q_r4c7 qb_r4c7 vdd vss cim_bitcell
Xcell_r5_c0 bl0 blb0 wl5 wwl5 q_r5c0 qb_r5c0 vdd vss cim_bitcell
Xcell_r5_c1 bl1 blb1 wl5 wwl5 q_r5c1 qb_r5c1 vdd vss cim_bitcell
Xcell_r5_c2 bl2 blb2 wl5 wwl5 q_r5c2 qb_r5c2 vdd vss cim_bitcell
Xcell_r5_c3 bl3 blb3 wl5 wwl5 q_r5c3 qb_r5c3 vdd vss cim_bitcell
Xcell_r5_c4 bl4 blb4 wl5 wwl5 q_r5c4 qb_r5c4 vdd vss cim_bitcell
Xcell_r5_c5 bl5 blb5 wl5 wwl5 q_r5c5 qb_r5c5 vdd vss cim_bitcell
Xcell_r5_c6 bl6 blb6 wl5 wwl5 q_r5c6 qb_r5c6 vdd vss cim_bitcell
Xcell_r5_c7 bl7 blb7 wl5 wwl5 q_r5c7 qb_r5c7 vdd vss cim_bitcell
Xcell_r6_c0 bl0 blb0 wl6 wwl6 q_r6c0 qb_r6c0 vdd vss cim_bitcell
Xcell_r6_c1 bl1 blb1 wl6 wwl6 q_r6c1 qb_r6c1 vdd vss cim_bitcell
Xcell_r6_c2 bl2 blb2 wl6 wwl6 q_r6c2 qb_r6c2 vdd vss cim_bitcell
Xcell_r6_c3 bl3 blb3 wl6 wwl6 q_r6c3 qb_r6c3 vdd vss cim_bitcell
Xcell_r6_c4 bl4 blb4 wl6 wwl6 q_r6c4 qb_r6c4 vdd vss cim_bitcell
Xcell_r6_c5 bl5 blb5 wl6 wwl6 q_r6c5 qb_r6c5 vdd vss cim_bitcell
Xcell_r6_c6 bl6 blb6 wl6 wwl6 q_r6c6 qb_r6c6 vdd vss cim_bitcell
Xcell_r6_c7 bl7 blb7 wl6 wwl6 q_r6c7 qb_r6c7 vdd vss cim_bitcell
Xcell_r7_c0 bl0 blb0 wl7 wwl7 q_r7c0 qb_r7c0 vdd vss cim_bitcell
Xcell_r7_c1 bl1 blb1 wl7 wwl7 q_r7c1 qb_r7c1 vdd vss cim_bitcell
Xcell_r7_c2 bl2 blb2 wl7 wwl7 q_r7c2 qb_r7c2 vdd vss cim_bitcell
Xcell_r7_c3 bl3 blb3 wl7 wwl7 q_r7c3 qb_r7c3 vdd vss cim_bitcell
Xcell_r7_c4 bl4 blb4 wl7 wwl7 q_r7c4 qb_r7c4 vdd vss cim_bitcell
Xcell_r7_c5 bl5 blb5 wl7 wwl7 q_r7c5 qb_r7c5 vdd vss cim_bitcell
Xcell_r7_c6 bl6 blb6 wl7 wwl7 q_r7c6 qb_r7c6 vdd vss cim_bitcell
Xcell_r7_c7 bl7 blb7 wl7 wwl7 q_r7c7 qb_r7c7 vdd vss cim_bitcell
Xcell_r8_c0 bl0 blb0 wl8 wwl8 q_r8c0 qb_r8c0 vdd vss cim_bitcell
Xcell_r8_c1 bl1 blb1 wl8 wwl8 q_r8c1 qb_r8c1 vdd vss cim_bitcell
Xcell_r8_c2 bl2 blb2 wl8 wwl8 q_r8c2 qb_r8c2 vdd vss cim_bitcell
Xcell_r8_c3 bl3 blb3 wl8 wwl8 q_r8c3 qb_r8c3 vdd vss cim_bitcell
Xcell_r8_c4 bl4 blb4 wl8 wwl8 q_r8c4 qb_r8c4 vdd vss cim_bitcell
Xcell_r8_c5 bl5 blb5 wl8 wwl8 q_r8c5 qb_r8c5 vdd vss cim_bitcell
Xcell_r8_c6 bl6 blb6 wl8 wwl8 q_r8c6 qb_r8c6 vdd vss cim_bitcell
Xcell_r8_c7 bl7 blb7 wl8 wwl8 q_r8c7 qb_r8c7 vdd vss cim_bitcell
Xcell_r9_c0 bl0 blb0 wl9 wwl9 q_r9c0 qb_r9c0 vdd vss cim_bitcell
Xcell_r9_c1 bl1 blb1 wl9 wwl9 q_r9c1 qb_r9c1 vdd vss cim_bitcell
Xcell_r9_c2 bl2 blb2 wl9 wwl9 q_r9c2 qb_r9c2 vdd vss cim_bitcell
Xcell_r9_c3 bl3 blb3 wl9 wwl9 q_r9c3 qb_r9c3 vdd vss cim_bitcell
Xcell_r9_c4 bl4 blb4 wl9 wwl9 q_r9c4 qb_r9c4 vdd vss cim_bitcell
Xcell_r9_c5 bl5 blb5 wl9 wwl9 q_r9c5 qb_r9c5 vdd vss cim_bitcell
Xcell_r9_c6 bl6 blb6 wl9 wwl9 q_r9c6 qb_r9c6 vdd vss cim_bitcell
Xcell_r9_c7 bl7 blb7 wl9 wwl9 q_r9c7 qb_r9c7 vdd vss cim_bitcell
Xcell_r10_c0 bl0 blb0 wl10 wwl10 q_r10c0 qb_r10c0 vdd vss cim_bitcell
Xcell_r10_c1 bl1 blb1 wl10 wwl10 q_r10c1 qb_r10c1 vdd vss cim_bitcell
Xcell_r10_c2 bl2 blb2 wl10 wwl10 q_r10c2 qb_r10c2 vdd vss cim_bitcell
Xcell_r10_c3 bl3 blb3 wl10 wwl10 q_r10c3 qb_r10c3 vdd vss cim_bitcell
Xcell_r10_c4 bl4 blb4 wl10 wwl10 q_r10c4 qb_r10c4 vdd vss cim_bitcell
Xcell_r10_c5 bl5 blb5 wl10 wwl10 q_r10c5 qb_r10c5 vdd vss cim_bitcell
Xcell_r10_c6 bl6 blb6 wl10 wwl10 q_r10c6 qb_r10c6 vdd vss cim_bitcell
Xcell_r10_c7 bl7 blb7 wl10 wwl10 q_r10c7 qb_r10c7 vdd vss cim_bitcell
Xcell_r11_c0 bl0 blb0 wl11 wwl11 q_r11c0 qb_r11c0 vdd vss cim_bitcell
Xcell_r11_c1 bl1 blb1 wl11 wwl11 q_r11c1 qb_r11c1 vdd vss cim_bitcell
Xcell_r11_c2 bl2 blb2 wl11 wwl11 q_r11c2 qb_r11c2 vdd vss cim_bitcell
Xcell_r11_c3 bl3 blb3 wl11 wwl11 q_r11c3 qb_r11c3 vdd vss cim_bitcell
Xcell_r11_c4 bl4 blb4 wl11 wwl11 q_r11c4 qb_r11c4 vdd vss cim_bitcell
Xcell_r11_c5 bl5 blb5 wl11 wwl11 q_r11c5 qb_r11c5 vdd vss cim_bitcell
Xcell_r11_c6 bl6 blb6 wl11 wwl11 q_r11c6 qb_r11c6 vdd vss cim_bitcell
Xcell_r11_c7 bl7 blb7 wl11 wwl11 q_r11c7 qb_r11c7 vdd vss cim_bitcell
Xcell_r12_c0 bl0 blb0 wl12 wwl12 q_r12c0 qb_r12c0 vdd vss cim_bitcell
Xcell_r12_c1 bl1 blb1 wl12 wwl12 q_r12c1 qb_r12c1 vdd vss cim_bitcell
Xcell_r12_c2 bl2 blb2 wl12 wwl12 q_r12c2 qb_r12c2 vdd vss cim_bitcell
Xcell_r12_c3 bl3 blb3 wl12 wwl12 q_r12c3 qb_r12c3 vdd vss cim_bitcell
Xcell_r12_c4 bl4 blb4 wl12 wwl12 q_r12c4 qb_r12c4 vdd vss cim_bitcell
Xcell_r12_c5 bl5 blb5 wl12 wwl12 q_r12c5 qb_r12c5 vdd vss cim_bitcell
Xcell_r12_c6 bl6 blb6 wl12 wwl12 q_r12c6 qb_r12c6 vdd vss cim_bitcell
Xcell_r12_c7 bl7 blb7 wl12 wwl12 q_r12c7 qb_r12c7 vdd vss cim_bitcell
Xcell_r13_c0 bl0 blb0 wl13 wwl13 q_r13c0 qb_r13c0 vdd vss cim_bitcell
Xcell_r13_c1 bl1 blb1 wl13 wwl13 q_r13c1 qb_r13c1 vdd vss cim_bitcell
Xcell_r13_c2 bl2 blb2 wl13 wwl13 q_r13c2 qb_r13c2 vdd vss cim_bitcell
Xcell_r13_c3 bl3 blb3 wl13 wwl13 q_r13c3 qb_r13c3 vdd vss cim_bitcell
Xcell_r13_c4 bl4 blb4 wl13 wwl13 q_r13c4 qb_r13c4 vdd vss cim_bitcell
Xcell_r13_c5 bl5 blb5 wl13 wwl13 q_r13c5 qb_r13c5 vdd vss cim_bitcell
Xcell_r13_c6 bl6 blb6 wl13 wwl13 q_r13c6 qb_r13c6 vdd vss cim_bitcell
Xcell_r13_c7 bl7 blb7 wl13 wwl13 q_r13c7 qb_r13c7 vdd vss cim_bitcell
Xcell_r14_c0 bl0 blb0 wl14 wwl14 q_r14c0 qb_r14c0 vdd vss cim_bitcell
Xcell_r14_c1 bl1 blb1 wl14 wwl14 q_r14c1 qb_r14c1 vdd vss cim_bitcell
Xcell_r14_c2 bl2 blb2 wl14 wwl14 q_r14c2 qb_r14c2 vdd vss cim_bitcell
Xcell_r14_c3 bl3 blb3 wl14 wwl14 q_r14c3 qb_r14c3 vdd vss cim_bitcell
Xcell_r14_c4 bl4 blb4 wl14 wwl14 q_r14c4 qb_r14c4 vdd vss cim_bitcell
Xcell_r14_c5 bl5 blb5 wl14 wwl14 q_r14c5 qb_r14c5 vdd vss cim_bitcell
Xcell_r14_c6 bl6 blb6 wl14 wwl14 q_r14c6 qb_r14c6 vdd vss cim_bitcell
Xcell_r14_c7 bl7 blb7 wl14 wwl14 q_r14c7 qb_r14c7 vdd vss cim_bitcell
Xcell_r15_c0 bl0 blb0 wl15 wwl15 q_r15c0 qb_r15c0 vdd vss cim_bitcell
Xcell_r15_c1 bl1 blb1 wl15 wwl15 q_r15c1 qb_r15c1 vdd vss cim_bitcell
Xcell_r15_c2 bl2 blb2 wl15 wwl15 q_r15c2 qb_r15c2 vdd vss cim_bitcell
Xcell_r15_c3 bl3 blb3 wl15 wwl15 q_r15c3 qb_r15c3 vdd vss cim_bitcell
Xcell_r15_c4 bl4 blb4 wl15 wwl15 q_r15c4 qb_r15c4 vdd vss cim_bitcell
Xcell_r15_c5 bl5 blb5 wl15 wwl15 q_r15c5 qb_r15c5 vdd vss cim_bitcell
Xcell_r15_c6 bl6 blb6 wl15 wwl15 q_r15c6 qb_r15c6 vdd vss cim_bitcell
Xcell_r15_c7 bl7 blb7 wl15 wwl15 q_r15c7 qb_r15c7 vdd vss cim_bitcell
Xcell_r16_c0 bl0 blb0 wl16 wwl16 q_r16c0 qb_r16c0 vdd vss cim_bitcell
Xcell_r16_c1 bl1 blb1 wl16 wwl16 q_r16c1 qb_r16c1 vdd vss cim_bitcell
Xcell_r16_c2 bl2 blb2 wl16 wwl16 q_r16c2 qb_r16c2 vdd vss cim_bitcell
Xcell_r16_c3 bl3 blb3 wl16 wwl16 q_r16c3 qb_r16c3 vdd vss cim_bitcell
Xcell_r16_c4 bl4 blb4 wl16 wwl16 q_r16c4 qb_r16c4 vdd vss cim_bitcell
Xcell_r16_c5 bl5 blb5 wl16 wwl16 q_r16c5 qb_r16c5 vdd vss cim_bitcell
Xcell_r16_c6 bl6 blb6 wl16 wwl16 q_r16c6 qb_r16c6 vdd vss cim_bitcell
Xcell_r16_c7 bl7 blb7 wl16 wwl16 q_r16c7 qb_r16c7 vdd vss cim_bitcell
Xcell_r17_c0 bl0 blb0 wl17 wwl17 q_r17c0 qb_r17c0 vdd vss cim_bitcell
Xcell_r17_c1 bl1 blb1 wl17 wwl17 q_r17c1 qb_r17c1 vdd vss cim_bitcell
Xcell_r17_c2 bl2 blb2 wl17 wwl17 q_r17c2 qb_r17c2 vdd vss cim_bitcell
Xcell_r17_c3 bl3 blb3 wl17 wwl17 q_r17c3 qb_r17c3 vdd vss cim_bitcell
Xcell_r17_c4 bl4 blb4 wl17 wwl17 q_r17c4 qb_r17c4 vdd vss cim_bitcell
Xcell_r17_c5 bl5 blb5 wl17 wwl17 q_r17c5 qb_r17c5 vdd vss cim_bitcell
Xcell_r17_c6 bl6 blb6 wl17 wwl17 q_r17c6 qb_r17c6 vdd vss cim_bitcell
Xcell_r17_c7 bl7 blb7 wl17 wwl17 q_r17c7 qb_r17c7 vdd vss cim_bitcell
Xcell_r18_c0 bl0 blb0 wl18 wwl18 q_r18c0 qb_r18c0 vdd vss cim_bitcell
Xcell_r18_c1 bl1 blb1 wl18 wwl18 q_r18c1 qb_r18c1 vdd vss cim_bitcell
Xcell_r18_c2 bl2 blb2 wl18 wwl18 q_r18c2 qb_r18c2 vdd vss cim_bitcell
Xcell_r18_c3 bl3 blb3 wl18 wwl18 q_r18c3 qb_r18c3 vdd vss cim_bitcell
Xcell_r18_c4 bl4 blb4 wl18 wwl18 q_r18c4 qb_r18c4 vdd vss cim_bitcell
Xcell_r18_c5 bl5 blb5 wl18 wwl18 q_r18c5 qb_r18c5 vdd vss cim_bitcell
Xcell_r18_c6 bl6 blb6 wl18 wwl18 q_r18c6 qb_r18c6 vdd vss cim_bitcell
Xcell_r18_c7 bl7 blb7 wl18 wwl18 q_r18c7 qb_r18c7 vdd vss cim_bitcell
Xcell_r19_c0 bl0 blb0 wl19 wwl19 q_r19c0 qb_r19c0 vdd vss cim_bitcell
Xcell_r19_c1 bl1 blb1 wl19 wwl19 q_r19c1 qb_r19c1 vdd vss cim_bitcell
Xcell_r19_c2 bl2 blb2 wl19 wwl19 q_r19c2 qb_r19c2 vdd vss cim_bitcell
Xcell_r19_c3 bl3 blb3 wl19 wwl19 q_r19c3 qb_r19c3 vdd vss cim_bitcell
Xcell_r19_c4 bl4 blb4 wl19 wwl19 q_r19c4 qb_r19c4 vdd vss cim_bitcell
Xcell_r19_c5 bl5 blb5 wl19 wwl19 q_r19c5 qb_r19c5 vdd vss cim_bitcell
Xcell_r19_c6 bl6 blb6 wl19 wwl19 q_r19c6 qb_r19c6 vdd vss cim_bitcell
Xcell_r19_c7 bl7 blb7 wl19 wwl19 q_r19c7 qb_r19c7 vdd vss cim_bitcell
Xcell_r20_c0 bl0 blb0 wl20 wwl20 q_r20c0 qb_r20c0 vdd vss cim_bitcell
Xcell_r20_c1 bl1 blb1 wl20 wwl20 q_r20c1 qb_r20c1 vdd vss cim_bitcell
Xcell_r20_c2 bl2 blb2 wl20 wwl20 q_r20c2 qb_r20c2 vdd vss cim_bitcell
Xcell_r20_c3 bl3 blb3 wl20 wwl20 q_r20c3 qb_r20c3 vdd vss cim_bitcell
Xcell_r20_c4 bl4 blb4 wl20 wwl20 q_r20c4 qb_r20c4 vdd vss cim_bitcell
Xcell_r20_c5 bl5 blb5 wl20 wwl20 q_r20c5 qb_r20c5 vdd vss cim_bitcell
Xcell_r20_c6 bl6 blb6 wl20 wwl20 q_r20c6 qb_r20c6 vdd vss cim_bitcell
Xcell_r20_c7 bl7 blb7 wl20 wwl20 q_r20c7 qb_r20c7 vdd vss cim_bitcell
Xcell_r21_c0 bl0 blb0 wl21 wwl21 q_r21c0 qb_r21c0 vdd vss cim_bitcell
Xcell_r21_c1 bl1 blb1 wl21 wwl21 q_r21c1 qb_r21c1 vdd vss cim_bitcell
Xcell_r21_c2 bl2 blb2 wl21 wwl21 q_r21c2 qb_r21c2 vdd vss cim_bitcell
Xcell_r21_c3 bl3 blb3 wl21 wwl21 q_r21c3 qb_r21c3 vdd vss cim_bitcell
Xcell_r21_c4 bl4 blb4 wl21 wwl21 q_r21c4 qb_r21c4 vdd vss cim_bitcell
Xcell_r21_c5 bl5 blb5 wl21 wwl21 q_r21c5 qb_r21c5 vdd vss cim_bitcell
Xcell_r21_c6 bl6 blb6 wl21 wwl21 q_r21c6 qb_r21c6 vdd vss cim_bitcell
Xcell_r21_c7 bl7 blb7 wl21 wwl21 q_r21c7 qb_r21c7 vdd vss cim_bitcell
Xcell_r22_c0 bl0 blb0 wl22 wwl22 q_r22c0 qb_r22c0 vdd vss cim_bitcell
Xcell_r22_c1 bl1 blb1 wl22 wwl22 q_r22c1 qb_r22c1 vdd vss cim_bitcell
Xcell_r22_c2 bl2 blb2 wl22 wwl22 q_r22c2 qb_r22c2 vdd vss cim_bitcell
Xcell_r22_c3 bl3 blb3 wl22 wwl22 q_r22c3 qb_r22c3 vdd vss cim_bitcell
Xcell_r22_c4 bl4 blb4 wl22 wwl22 q_r22c4 qb_r22c4 vdd vss cim_bitcell
Xcell_r22_c5 bl5 blb5 wl22 wwl22 q_r22c5 qb_r22c5 vdd vss cim_bitcell
Xcell_r22_c6 bl6 blb6 wl22 wwl22 q_r22c6 qb_r22c6 vdd vss cim_bitcell
Xcell_r22_c7 bl7 blb7 wl22 wwl22 q_r22c7 qb_r22c7 vdd vss cim_bitcell
Xcell_r23_c0 bl0 blb0 wl23 wwl23 q_r23c0 qb_r23c0 vdd vss cim_bitcell
Xcell_r23_c1 bl1 blb1 wl23 wwl23 q_r23c1 qb_r23c1 vdd vss cim_bitcell
Xcell_r23_c2 bl2 blb2 wl23 wwl23 q_r23c2 qb_r23c2 vdd vss cim_bitcell
Xcell_r23_c3 bl3 blb3 wl23 wwl23 q_r23c3 qb_r23c3 vdd vss cim_bitcell
Xcell_r23_c4 bl4 blb4 wl23 wwl23 q_r23c4 qb_r23c4 vdd vss cim_bitcell
Xcell_r23_c5 bl5 blb5 wl23 wwl23 q_r23c5 qb_r23c5 vdd vss cim_bitcell
Xcell_r23_c6 bl6 blb6 wl23 wwl23 q_r23c6 qb_r23c6 vdd vss cim_bitcell
Xcell_r23_c7 bl7 blb7 wl23 wwl23 q_r23c7 qb_r23c7 vdd vss cim_bitcell
Xcell_r24_c0 bl0 blb0 wl24 wwl24 q_r24c0 qb_r24c0 vdd vss cim_bitcell
Xcell_r24_c1 bl1 blb1 wl24 wwl24 q_r24c1 qb_r24c1 vdd vss cim_bitcell
Xcell_r24_c2 bl2 blb2 wl24 wwl24 q_r24c2 qb_r24c2 vdd vss cim_bitcell
Xcell_r24_c3 bl3 blb3 wl24 wwl24 q_r24c3 qb_r24c3 vdd vss cim_bitcell
Xcell_r24_c4 bl4 blb4 wl24 wwl24 q_r24c4 qb_r24c4 vdd vss cim_bitcell
Xcell_r24_c5 bl5 blb5 wl24 wwl24 q_r24c5 qb_r24c5 vdd vss cim_bitcell
Xcell_r24_c6 bl6 blb6 wl24 wwl24 q_r24c6 qb_r24c6 vdd vss cim_bitcell
Xcell_r24_c7 bl7 blb7 wl24 wwl24 q_r24c7 qb_r24c7 vdd vss cim_bitcell
Xcell_r25_c0 bl0 blb0 wl25 wwl25 q_r25c0 qb_r25c0 vdd vss cim_bitcell
Xcell_r25_c1 bl1 blb1 wl25 wwl25 q_r25c1 qb_r25c1 vdd vss cim_bitcell
Xcell_r25_c2 bl2 blb2 wl25 wwl25 q_r25c2 qb_r25c2 vdd vss cim_bitcell
Xcell_r25_c3 bl3 blb3 wl25 wwl25 q_r25c3 qb_r25c3 vdd vss cim_bitcell
Xcell_r25_c4 bl4 blb4 wl25 wwl25 q_r25c4 qb_r25c4 vdd vss cim_bitcell
Xcell_r25_c5 bl5 blb5 wl25 wwl25 q_r25c5 qb_r25c5 vdd vss cim_bitcell
Xcell_r25_c6 bl6 blb6 wl25 wwl25 q_r25c6 qb_r25c6 vdd vss cim_bitcell
Xcell_r25_c7 bl7 blb7 wl25 wwl25 q_r25c7 qb_r25c7 vdd vss cim_bitcell
Xcell_r26_c0 bl0 blb0 wl26 wwl26 q_r26c0 qb_r26c0 vdd vss cim_bitcell
Xcell_r26_c1 bl1 blb1 wl26 wwl26 q_r26c1 qb_r26c1 vdd vss cim_bitcell
Xcell_r26_c2 bl2 blb2 wl26 wwl26 q_r26c2 qb_r26c2 vdd vss cim_bitcell
Xcell_r26_c3 bl3 blb3 wl26 wwl26 q_r26c3 qb_r26c3 vdd vss cim_bitcell
Xcell_r26_c4 bl4 blb4 wl26 wwl26 q_r26c4 qb_r26c4 vdd vss cim_bitcell
Xcell_r26_c5 bl5 blb5 wl26 wwl26 q_r26c5 qb_r26c5 vdd vss cim_bitcell
Xcell_r26_c6 bl6 blb6 wl26 wwl26 q_r26c6 qb_r26c6 vdd vss cim_bitcell
Xcell_r26_c7 bl7 blb7 wl26 wwl26 q_r26c7 qb_r26c7 vdd vss cim_bitcell
Xcell_r27_c0 bl0 blb0 wl27 wwl27 q_r27c0 qb_r27c0 vdd vss cim_bitcell
Xcell_r27_c1 bl1 blb1 wl27 wwl27 q_r27c1 qb_r27c1 vdd vss cim_bitcell
Xcell_r27_c2 bl2 blb2 wl27 wwl27 q_r27c2 qb_r27c2 vdd vss cim_bitcell
Xcell_r27_c3 bl3 blb3 wl27 wwl27 q_r27c3 qb_r27c3 vdd vss cim_bitcell
Xcell_r27_c4 bl4 blb4 wl27 wwl27 q_r27c4 qb_r27c4 vdd vss cim_bitcell
Xcell_r27_c5 bl5 blb5 wl27 wwl27 q_r27c5 qb_r27c5 vdd vss cim_bitcell
Xcell_r27_c6 bl6 blb6 wl27 wwl27 q_r27c6 qb_r27c6 vdd vss cim_bitcell
Xcell_r27_c7 bl7 blb7 wl27 wwl27 q_r27c7 qb_r27c7 vdd vss cim_bitcell
Xcell_r28_c0 bl0 blb0 wl28 wwl28 q_r28c0 qb_r28c0 vdd vss cim_bitcell
Xcell_r28_c1 bl1 blb1 wl28 wwl28 q_r28c1 qb_r28c1 vdd vss cim_bitcell
Xcell_r28_c2 bl2 blb2 wl28 wwl28 q_r28c2 qb_r28c2 vdd vss cim_bitcell
Xcell_r28_c3 bl3 blb3 wl28 wwl28 q_r28c3 qb_r28c3 vdd vss cim_bitcell
Xcell_r28_c4 bl4 blb4 wl28 wwl28 q_r28c4 qb_r28c4 vdd vss cim_bitcell
Xcell_r28_c5 bl5 blb5 wl28 wwl28 q_r28c5 qb_r28c5 vdd vss cim_bitcell
Xcell_r28_c6 bl6 blb6 wl28 wwl28 q_r28c6 qb_r28c6 vdd vss cim_bitcell
Xcell_r28_c7 bl7 blb7 wl28 wwl28 q_r28c7 qb_r28c7 vdd vss cim_bitcell
Xcell_r29_c0 bl0 blb0 wl29 wwl29 q_r29c0 qb_r29c0 vdd vss cim_bitcell
Xcell_r29_c1 bl1 blb1 wl29 wwl29 q_r29c1 qb_r29c1 vdd vss cim_bitcell
Xcell_r29_c2 bl2 blb2 wl29 wwl29 q_r29c2 qb_r29c2 vdd vss cim_bitcell
Xcell_r29_c3 bl3 blb3 wl29 wwl29 q_r29c3 qb_r29c3 vdd vss cim_bitcell
Xcell_r29_c4 bl4 blb4 wl29 wwl29 q_r29c4 qb_r29c4 vdd vss cim_bitcell
Xcell_r29_c5 bl5 blb5 wl29 wwl29 q_r29c5 qb_r29c5 vdd vss cim_bitcell
Xcell_r29_c6 bl6 blb6 wl29 wwl29 q_r29c6 qb_r29c6 vdd vss cim_bitcell
Xcell_r29_c7 bl7 blb7 wl29 wwl29 q_r29c7 qb_r29c7 vdd vss cim_bitcell
Xcell_r30_c0 bl0 blb0 wl30 wwl30 q_r30c0 qb_r30c0 vdd vss cim_bitcell
Xcell_r30_c1 bl1 blb1 wl30 wwl30 q_r30c1 qb_r30c1 vdd vss cim_bitcell
Xcell_r30_c2 bl2 blb2 wl30 wwl30 q_r30c2 qb_r30c2 vdd vss cim_bitcell
Xcell_r30_c3 bl3 blb3 wl30 wwl30 q_r30c3 qb_r30c3 vdd vss cim_bitcell
Xcell_r30_c4 bl4 blb4 wl30 wwl30 q_r30c4 qb_r30c4 vdd vss cim_bitcell
Xcell_r30_c5 bl5 blb5 wl30 wwl30 q_r30c5 qb_r30c5 vdd vss cim_bitcell
Xcell_r30_c6 bl6 blb6 wl30 wwl30 q_r30c6 qb_r30c6 vdd vss cim_bitcell
Xcell_r30_c7 bl7 blb7 wl30 wwl30 q_r30c7 qb_r30c7 vdd vss cim_bitcell
Xcell_r31_c0 bl0 blb0 wl31 wwl31 q_r31c0 qb_r31c0 vdd vss cim_bitcell
Xcell_r31_c1 bl1 blb1 wl31 wwl31 q_r31c1 qb_r31c1 vdd vss cim_bitcell
Xcell_r31_c2 bl2 blb2 wl31 wwl31 q_r31c2 qb_r31c2 vdd vss cim_bitcell
Xcell_r31_c3 bl3 blb3 wl31 wwl31 q_r31c3 qb_r31c3 vdd vss cim_bitcell
Xcell_r31_c4 bl4 blb4 wl31 wwl31 q_r31c4 qb_r31c4 vdd vss cim_bitcell
Xcell_r31_c5 bl5 blb5 wl31 wwl31 q_r31c5 qb_r31c5 vdd vss cim_bitcell
Xcell_r31_c6 bl6 blb6 wl31 wwl31 q_r31c6 qb_r31c6 vdd vss cim_bitcell
Xcell_r31_c7 bl7 blb7 wl31 wwl31 q_r31c7 qb_r31c7 vdd vss cim_bitcell
Xcell_r32_c0 bl0 blb0 wl32 wwl32 q_r32c0 qb_r32c0 vdd vss cim_bitcell
Xcell_r32_c1 bl1 blb1 wl32 wwl32 q_r32c1 qb_r32c1 vdd vss cim_bitcell
Xcell_r32_c2 bl2 blb2 wl32 wwl32 q_r32c2 qb_r32c2 vdd vss cim_bitcell
Xcell_r32_c3 bl3 blb3 wl32 wwl32 q_r32c3 qb_r32c3 vdd vss cim_bitcell
Xcell_r32_c4 bl4 blb4 wl32 wwl32 q_r32c4 qb_r32c4 vdd vss cim_bitcell
Xcell_r32_c5 bl5 blb5 wl32 wwl32 q_r32c5 qb_r32c5 vdd vss cim_bitcell
Xcell_r32_c6 bl6 blb6 wl32 wwl32 q_r32c6 qb_r32c6 vdd vss cim_bitcell
Xcell_r32_c7 bl7 blb7 wl32 wwl32 q_r32c7 qb_r32c7 vdd vss cim_bitcell
Xcell_r33_c0 bl0 blb0 wl33 wwl33 q_r33c0 qb_r33c0 vdd vss cim_bitcell
Xcell_r33_c1 bl1 blb1 wl33 wwl33 q_r33c1 qb_r33c1 vdd vss cim_bitcell
Xcell_r33_c2 bl2 blb2 wl33 wwl33 q_r33c2 qb_r33c2 vdd vss cim_bitcell
Xcell_r33_c3 bl3 blb3 wl33 wwl33 q_r33c3 qb_r33c3 vdd vss cim_bitcell
Xcell_r33_c4 bl4 blb4 wl33 wwl33 q_r33c4 qb_r33c4 vdd vss cim_bitcell
Xcell_r33_c5 bl5 blb5 wl33 wwl33 q_r33c5 qb_r33c5 vdd vss cim_bitcell
Xcell_r33_c6 bl6 blb6 wl33 wwl33 q_r33c6 qb_r33c6 vdd vss cim_bitcell
Xcell_r33_c7 bl7 blb7 wl33 wwl33 q_r33c7 qb_r33c7 vdd vss cim_bitcell
Xcell_r34_c0 bl0 blb0 wl34 wwl34 q_r34c0 qb_r34c0 vdd vss cim_bitcell
Xcell_r34_c1 bl1 blb1 wl34 wwl34 q_r34c1 qb_r34c1 vdd vss cim_bitcell
Xcell_r34_c2 bl2 blb2 wl34 wwl34 q_r34c2 qb_r34c2 vdd vss cim_bitcell
Xcell_r34_c3 bl3 blb3 wl34 wwl34 q_r34c3 qb_r34c3 vdd vss cim_bitcell
Xcell_r34_c4 bl4 blb4 wl34 wwl34 q_r34c4 qb_r34c4 vdd vss cim_bitcell
Xcell_r34_c5 bl5 blb5 wl34 wwl34 q_r34c5 qb_r34c5 vdd vss cim_bitcell
Xcell_r34_c6 bl6 blb6 wl34 wwl34 q_r34c6 qb_r34c6 vdd vss cim_bitcell
Xcell_r34_c7 bl7 blb7 wl34 wwl34 q_r34c7 qb_r34c7 vdd vss cim_bitcell
Xcell_r35_c0 bl0 blb0 wl35 wwl35 q_r35c0 qb_r35c0 vdd vss cim_bitcell
Xcell_r35_c1 bl1 blb1 wl35 wwl35 q_r35c1 qb_r35c1 vdd vss cim_bitcell
Xcell_r35_c2 bl2 blb2 wl35 wwl35 q_r35c2 qb_r35c2 vdd vss cim_bitcell
Xcell_r35_c3 bl3 blb3 wl35 wwl35 q_r35c3 qb_r35c3 vdd vss cim_bitcell
Xcell_r35_c4 bl4 blb4 wl35 wwl35 q_r35c4 qb_r35c4 vdd vss cim_bitcell
Xcell_r35_c5 bl5 blb5 wl35 wwl35 q_r35c5 qb_r35c5 vdd vss cim_bitcell
Xcell_r35_c6 bl6 blb6 wl35 wwl35 q_r35c6 qb_r35c6 vdd vss cim_bitcell
Xcell_r35_c7 bl7 blb7 wl35 wwl35 q_r35c7 qb_r35c7 vdd vss cim_bitcell
Xcell_r36_c0 bl0 blb0 wl36 wwl36 q_r36c0 qb_r36c0 vdd vss cim_bitcell
Xcell_r36_c1 bl1 blb1 wl36 wwl36 q_r36c1 qb_r36c1 vdd vss cim_bitcell
Xcell_r36_c2 bl2 blb2 wl36 wwl36 q_r36c2 qb_r36c2 vdd vss cim_bitcell
Xcell_r36_c3 bl3 blb3 wl36 wwl36 q_r36c3 qb_r36c3 vdd vss cim_bitcell
Xcell_r36_c4 bl4 blb4 wl36 wwl36 q_r36c4 qb_r36c4 vdd vss cim_bitcell
Xcell_r36_c5 bl5 blb5 wl36 wwl36 q_r36c5 qb_r36c5 vdd vss cim_bitcell
Xcell_r36_c6 bl6 blb6 wl36 wwl36 q_r36c6 qb_r36c6 vdd vss cim_bitcell
Xcell_r36_c7 bl7 blb7 wl36 wwl36 q_r36c7 qb_r36c7 vdd vss cim_bitcell
Xcell_r37_c0 bl0 blb0 wl37 wwl37 q_r37c0 qb_r37c0 vdd vss cim_bitcell
Xcell_r37_c1 bl1 blb1 wl37 wwl37 q_r37c1 qb_r37c1 vdd vss cim_bitcell
Xcell_r37_c2 bl2 blb2 wl37 wwl37 q_r37c2 qb_r37c2 vdd vss cim_bitcell
Xcell_r37_c3 bl3 blb3 wl37 wwl37 q_r37c3 qb_r37c3 vdd vss cim_bitcell
Xcell_r37_c4 bl4 blb4 wl37 wwl37 q_r37c4 qb_r37c4 vdd vss cim_bitcell
Xcell_r37_c5 bl5 blb5 wl37 wwl37 q_r37c5 qb_r37c5 vdd vss cim_bitcell
Xcell_r37_c6 bl6 blb6 wl37 wwl37 q_r37c6 qb_r37c6 vdd vss cim_bitcell
Xcell_r37_c7 bl7 blb7 wl37 wwl37 q_r37c7 qb_r37c7 vdd vss cim_bitcell
Xcell_r38_c0 bl0 blb0 wl38 wwl38 q_r38c0 qb_r38c0 vdd vss cim_bitcell
Xcell_r38_c1 bl1 blb1 wl38 wwl38 q_r38c1 qb_r38c1 vdd vss cim_bitcell
Xcell_r38_c2 bl2 blb2 wl38 wwl38 q_r38c2 qb_r38c2 vdd vss cim_bitcell
Xcell_r38_c3 bl3 blb3 wl38 wwl38 q_r38c3 qb_r38c3 vdd vss cim_bitcell
Xcell_r38_c4 bl4 blb4 wl38 wwl38 q_r38c4 qb_r38c4 vdd vss cim_bitcell
Xcell_r38_c5 bl5 blb5 wl38 wwl38 q_r38c5 qb_r38c5 vdd vss cim_bitcell
Xcell_r38_c6 bl6 blb6 wl38 wwl38 q_r38c6 qb_r38c6 vdd vss cim_bitcell
Xcell_r38_c7 bl7 blb7 wl38 wwl38 q_r38c7 qb_r38c7 vdd vss cim_bitcell
Xcell_r39_c0 bl0 blb0 wl39 wwl39 q_r39c0 qb_r39c0 vdd vss cim_bitcell
Xcell_r39_c1 bl1 blb1 wl39 wwl39 q_r39c1 qb_r39c1 vdd vss cim_bitcell
Xcell_r39_c2 bl2 blb2 wl39 wwl39 q_r39c2 qb_r39c2 vdd vss cim_bitcell
Xcell_r39_c3 bl3 blb3 wl39 wwl39 q_r39c3 qb_r39c3 vdd vss cim_bitcell
Xcell_r39_c4 bl4 blb4 wl39 wwl39 q_r39c4 qb_r39c4 vdd vss cim_bitcell
Xcell_r39_c5 bl5 blb5 wl39 wwl39 q_r39c5 qb_r39c5 vdd vss cim_bitcell
Xcell_r39_c6 bl6 blb6 wl39 wwl39 q_r39c6 qb_r39c6 vdd vss cim_bitcell
Xcell_r39_c7 bl7 blb7 wl39 wwl39 q_r39c7 qb_r39c7 vdd vss cim_bitcell
Xcell_r40_c0 bl0 blb0 wl40 wwl40 q_r40c0 qb_r40c0 vdd vss cim_bitcell
Xcell_r40_c1 bl1 blb1 wl40 wwl40 q_r40c1 qb_r40c1 vdd vss cim_bitcell
Xcell_r40_c2 bl2 blb2 wl40 wwl40 q_r40c2 qb_r40c2 vdd vss cim_bitcell
Xcell_r40_c3 bl3 blb3 wl40 wwl40 q_r40c3 qb_r40c3 vdd vss cim_bitcell
Xcell_r40_c4 bl4 blb4 wl40 wwl40 q_r40c4 qb_r40c4 vdd vss cim_bitcell
Xcell_r40_c5 bl5 blb5 wl40 wwl40 q_r40c5 qb_r40c5 vdd vss cim_bitcell
Xcell_r40_c6 bl6 blb6 wl40 wwl40 q_r40c6 qb_r40c6 vdd vss cim_bitcell
Xcell_r40_c7 bl7 blb7 wl40 wwl40 q_r40c7 qb_r40c7 vdd vss cim_bitcell
Xcell_r41_c0 bl0 blb0 wl41 wwl41 q_r41c0 qb_r41c0 vdd vss cim_bitcell
Xcell_r41_c1 bl1 blb1 wl41 wwl41 q_r41c1 qb_r41c1 vdd vss cim_bitcell
Xcell_r41_c2 bl2 blb2 wl41 wwl41 q_r41c2 qb_r41c2 vdd vss cim_bitcell
Xcell_r41_c3 bl3 blb3 wl41 wwl41 q_r41c3 qb_r41c3 vdd vss cim_bitcell
Xcell_r41_c4 bl4 blb4 wl41 wwl41 q_r41c4 qb_r41c4 vdd vss cim_bitcell
Xcell_r41_c5 bl5 blb5 wl41 wwl41 q_r41c5 qb_r41c5 vdd vss cim_bitcell
Xcell_r41_c6 bl6 blb6 wl41 wwl41 q_r41c6 qb_r41c6 vdd vss cim_bitcell
Xcell_r41_c7 bl7 blb7 wl41 wwl41 q_r41c7 qb_r41c7 vdd vss cim_bitcell
Xcell_r42_c0 bl0 blb0 wl42 wwl42 q_r42c0 qb_r42c0 vdd vss cim_bitcell
Xcell_r42_c1 bl1 blb1 wl42 wwl42 q_r42c1 qb_r42c1 vdd vss cim_bitcell
Xcell_r42_c2 bl2 blb2 wl42 wwl42 q_r42c2 qb_r42c2 vdd vss cim_bitcell
Xcell_r42_c3 bl3 blb3 wl42 wwl42 q_r42c3 qb_r42c3 vdd vss cim_bitcell
Xcell_r42_c4 bl4 blb4 wl42 wwl42 q_r42c4 qb_r42c4 vdd vss cim_bitcell
Xcell_r42_c5 bl5 blb5 wl42 wwl42 q_r42c5 qb_r42c5 vdd vss cim_bitcell
Xcell_r42_c6 bl6 blb6 wl42 wwl42 q_r42c6 qb_r42c6 vdd vss cim_bitcell
Xcell_r42_c7 bl7 blb7 wl42 wwl42 q_r42c7 qb_r42c7 vdd vss cim_bitcell
Xcell_r43_c0 bl0 blb0 wl43 wwl43 q_r43c0 qb_r43c0 vdd vss cim_bitcell
Xcell_r43_c1 bl1 blb1 wl43 wwl43 q_r43c1 qb_r43c1 vdd vss cim_bitcell
Xcell_r43_c2 bl2 blb2 wl43 wwl43 q_r43c2 qb_r43c2 vdd vss cim_bitcell
Xcell_r43_c3 bl3 blb3 wl43 wwl43 q_r43c3 qb_r43c3 vdd vss cim_bitcell
Xcell_r43_c4 bl4 blb4 wl43 wwl43 q_r43c4 qb_r43c4 vdd vss cim_bitcell
Xcell_r43_c5 bl5 blb5 wl43 wwl43 q_r43c5 qb_r43c5 vdd vss cim_bitcell
Xcell_r43_c6 bl6 blb6 wl43 wwl43 q_r43c6 qb_r43c6 vdd vss cim_bitcell
Xcell_r43_c7 bl7 blb7 wl43 wwl43 q_r43c7 qb_r43c7 vdd vss cim_bitcell
Xcell_r44_c0 bl0 blb0 wl44 wwl44 q_r44c0 qb_r44c0 vdd vss cim_bitcell
Xcell_r44_c1 bl1 blb1 wl44 wwl44 q_r44c1 qb_r44c1 vdd vss cim_bitcell
Xcell_r44_c2 bl2 blb2 wl44 wwl44 q_r44c2 qb_r44c2 vdd vss cim_bitcell
Xcell_r44_c3 bl3 blb3 wl44 wwl44 q_r44c3 qb_r44c3 vdd vss cim_bitcell
Xcell_r44_c4 bl4 blb4 wl44 wwl44 q_r44c4 qb_r44c4 vdd vss cim_bitcell
Xcell_r44_c5 bl5 blb5 wl44 wwl44 q_r44c5 qb_r44c5 vdd vss cim_bitcell
Xcell_r44_c6 bl6 blb6 wl44 wwl44 q_r44c6 qb_r44c6 vdd vss cim_bitcell
Xcell_r44_c7 bl7 blb7 wl44 wwl44 q_r44c7 qb_r44c7 vdd vss cim_bitcell
Xcell_r45_c0 bl0 blb0 wl45 wwl45 q_r45c0 qb_r45c0 vdd vss cim_bitcell
Xcell_r45_c1 bl1 blb1 wl45 wwl45 q_r45c1 qb_r45c1 vdd vss cim_bitcell
Xcell_r45_c2 bl2 blb2 wl45 wwl45 q_r45c2 qb_r45c2 vdd vss cim_bitcell
Xcell_r45_c3 bl3 blb3 wl45 wwl45 q_r45c3 qb_r45c3 vdd vss cim_bitcell
Xcell_r45_c4 bl4 blb4 wl45 wwl45 q_r45c4 qb_r45c4 vdd vss cim_bitcell
Xcell_r45_c5 bl5 blb5 wl45 wwl45 q_r45c5 qb_r45c5 vdd vss cim_bitcell
Xcell_r45_c6 bl6 blb6 wl45 wwl45 q_r45c6 qb_r45c6 vdd vss cim_bitcell
Xcell_r45_c7 bl7 blb7 wl45 wwl45 q_r45c7 qb_r45c7 vdd vss cim_bitcell
Xcell_r46_c0 bl0 blb0 wl46 wwl46 q_r46c0 qb_r46c0 vdd vss cim_bitcell
Xcell_r46_c1 bl1 blb1 wl46 wwl46 q_r46c1 qb_r46c1 vdd vss cim_bitcell
Xcell_r46_c2 bl2 blb2 wl46 wwl46 q_r46c2 qb_r46c2 vdd vss cim_bitcell
Xcell_r46_c3 bl3 blb3 wl46 wwl46 q_r46c3 qb_r46c3 vdd vss cim_bitcell
Xcell_r46_c4 bl4 blb4 wl46 wwl46 q_r46c4 qb_r46c4 vdd vss cim_bitcell
Xcell_r46_c5 bl5 blb5 wl46 wwl46 q_r46c5 qb_r46c5 vdd vss cim_bitcell
Xcell_r46_c6 bl6 blb6 wl46 wwl46 q_r46c6 qb_r46c6 vdd vss cim_bitcell
Xcell_r46_c7 bl7 blb7 wl46 wwl46 q_r46c7 qb_r46c7 vdd vss cim_bitcell
Xcell_r47_c0 bl0 blb0 wl47 wwl47 q_r47c0 qb_r47c0 vdd vss cim_bitcell
Xcell_r47_c1 bl1 blb1 wl47 wwl47 q_r47c1 qb_r47c1 vdd vss cim_bitcell
Xcell_r47_c2 bl2 blb2 wl47 wwl47 q_r47c2 qb_r47c2 vdd vss cim_bitcell
Xcell_r47_c3 bl3 blb3 wl47 wwl47 q_r47c3 qb_r47c3 vdd vss cim_bitcell
Xcell_r47_c4 bl4 blb4 wl47 wwl47 q_r47c4 qb_r47c4 vdd vss cim_bitcell
Xcell_r47_c5 bl5 blb5 wl47 wwl47 q_r47c5 qb_r47c5 vdd vss cim_bitcell
Xcell_r47_c6 bl6 blb6 wl47 wwl47 q_r47c6 qb_r47c6 vdd vss cim_bitcell
Xcell_r47_c7 bl7 blb7 wl47 wwl47 q_r47c7 qb_r47c7 vdd vss cim_bitcell
Xcell_r48_c0 bl0 blb0 wl48 wwl48 q_r48c0 qb_r48c0 vdd vss cim_bitcell
Xcell_r48_c1 bl1 blb1 wl48 wwl48 q_r48c1 qb_r48c1 vdd vss cim_bitcell
Xcell_r48_c2 bl2 blb2 wl48 wwl48 q_r48c2 qb_r48c2 vdd vss cim_bitcell
Xcell_r48_c3 bl3 blb3 wl48 wwl48 q_r48c3 qb_r48c3 vdd vss cim_bitcell
Xcell_r48_c4 bl4 blb4 wl48 wwl48 q_r48c4 qb_r48c4 vdd vss cim_bitcell
Xcell_r48_c5 bl5 blb5 wl48 wwl48 q_r48c5 qb_r48c5 vdd vss cim_bitcell
Xcell_r48_c6 bl6 blb6 wl48 wwl48 q_r48c6 qb_r48c6 vdd vss cim_bitcell
Xcell_r48_c7 bl7 blb7 wl48 wwl48 q_r48c7 qb_r48c7 vdd vss cim_bitcell
Xcell_r49_c0 bl0 blb0 wl49 wwl49 q_r49c0 qb_r49c0 vdd vss cim_bitcell
Xcell_r49_c1 bl1 blb1 wl49 wwl49 q_r49c1 qb_r49c1 vdd vss cim_bitcell
Xcell_r49_c2 bl2 blb2 wl49 wwl49 q_r49c2 qb_r49c2 vdd vss cim_bitcell
Xcell_r49_c3 bl3 blb3 wl49 wwl49 q_r49c3 qb_r49c3 vdd vss cim_bitcell
Xcell_r49_c4 bl4 blb4 wl49 wwl49 q_r49c4 qb_r49c4 vdd vss cim_bitcell
Xcell_r49_c5 bl5 blb5 wl49 wwl49 q_r49c5 qb_r49c5 vdd vss cim_bitcell
Xcell_r49_c6 bl6 blb6 wl49 wwl49 q_r49c6 qb_r49c6 vdd vss cim_bitcell
Xcell_r49_c7 bl7 blb7 wl49 wwl49 q_r49c7 qb_r49c7 vdd vss cim_bitcell
Xcell_r50_c0 bl0 blb0 wl50 wwl50 q_r50c0 qb_r50c0 vdd vss cim_bitcell
Xcell_r50_c1 bl1 blb1 wl50 wwl50 q_r50c1 qb_r50c1 vdd vss cim_bitcell
Xcell_r50_c2 bl2 blb2 wl50 wwl50 q_r50c2 qb_r50c2 vdd vss cim_bitcell
Xcell_r50_c3 bl3 blb3 wl50 wwl50 q_r50c3 qb_r50c3 vdd vss cim_bitcell
Xcell_r50_c4 bl4 blb4 wl50 wwl50 q_r50c4 qb_r50c4 vdd vss cim_bitcell
Xcell_r50_c5 bl5 blb5 wl50 wwl50 q_r50c5 qb_r50c5 vdd vss cim_bitcell
Xcell_r50_c6 bl6 blb6 wl50 wwl50 q_r50c6 qb_r50c6 vdd vss cim_bitcell
Xcell_r50_c7 bl7 blb7 wl50 wwl50 q_r50c7 qb_r50c7 vdd vss cim_bitcell
Xcell_r51_c0 bl0 blb0 wl51 wwl51 q_r51c0 qb_r51c0 vdd vss cim_bitcell
Xcell_r51_c1 bl1 blb1 wl51 wwl51 q_r51c1 qb_r51c1 vdd vss cim_bitcell
Xcell_r51_c2 bl2 blb2 wl51 wwl51 q_r51c2 qb_r51c2 vdd vss cim_bitcell
Xcell_r51_c3 bl3 blb3 wl51 wwl51 q_r51c3 qb_r51c3 vdd vss cim_bitcell
Xcell_r51_c4 bl4 blb4 wl51 wwl51 q_r51c4 qb_r51c4 vdd vss cim_bitcell
Xcell_r51_c5 bl5 blb5 wl51 wwl51 q_r51c5 qb_r51c5 vdd vss cim_bitcell
Xcell_r51_c6 bl6 blb6 wl51 wwl51 q_r51c6 qb_r51c6 vdd vss cim_bitcell
Xcell_r51_c7 bl7 blb7 wl51 wwl51 q_r51c7 qb_r51c7 vdd vss cim_bitcell
Xcell_r52_c0 bl0 blb0 wl52 wwl52 q_r52c0 qb_r52c0 vdd vss cim_bitcell
Xcell_r52_c1 bl1 blb1 wl52 wwl52 q_r52c1 qb_r52c1 vdd vss cim_bitcell
Xcell_r52_c2 bl2 blb2 wl52 wwl52 q_r52c2 qb_r52c2 vdd vss cim_bitcell
Xcell_r52_c3 bl3 blb3 wl52 wwl52 q_r52c3 qb_r52c3 vdd vss cim_bitcell
Xcell_r52_c4 bl4 blb4 wl52 wwl52 q_r52c4 qb_r52c4 vdd vss cim_bitcell
Xcell_r52_c5 bl5 blb5 wl52 wwl52 q_r52c5 qb_r52c5 vdd vss cim_bitcell
Xcell_r52_c6 bl6 blb6 wl52 wwl52 q_r52c6 qb_r52c6 vdd vss cim_bitcell
Xcell_r52_c7 bl7 blb7 wl52 wwl52 q_r52c7 qb_r52c7 vdd vss cim_bitcell
Xcell_r53_c0 bl0 blb0 wl53 wwl53 q_r53c0 qb_r53c0 vdd vss cim_bitcell
Xcell_r53_c1 bl1 blb1 wl53 wwl53 q_r53c1 qb_r53c1 vdd vss cim_bitcell
Xcell_r53_c2 bl2 blb2 wl53 wwl53 q_r53c2 qb_r53c2 vdd vss cim_bitcell
Xcell_r53_c3 bl3 blb3 wl53 wwl53 q_r53c3 qb_r53c3 vdd vss cim_bitcell
Xcell_r53_c4 bl4 blb4 wl53 wwl53 q_r53c4 qb_r53c4 vdd vss cim_bitcell
Xcell_r53_c5 bl5 blb5 wl53 wwl53 q_r53c5 qb_r53c5 vdd vss cim_bitcell
Xcell_r53_c6 bl6 blb6 wl53 wwl53 q_r53c6 qb_r53c6 vdd vss cim_bitcell
Xcell_r53_c7 bl7 blb7 wl53 wwl53 q_r53c7 qb_r53c7 vdd vss cim_bitcell
Xcell_r54_c0 bl0 blb0 wl54 wwl54 q_r54c0 qb_r54c0 vdd vss cim_bitcell
Xcell_r54_c1 bl1 blb1 wl54 wwl54 q_r54c1 qb_r54c1 vdd vss cim_bitcell
Xcell_r54_c2 bl2 blb2 wl54 wwl54 q_r54c2 qb_r54c2 vdd vss cim_bitcell
Xcell_r54_c3 bl3 blb3 wl54 wwl54 q_r54c3 qb_r54c3 vdd vss cim_bitcell
Xcell_r54_c4 bl4 blb4 wl54 wwl54 q_r54c4 qb_r54c4 vdd vss cim_bitcell
Xcell_r54_c5 bl5 blb5 wl54 wwl54 q_r54c5 qb_r54c5 vdd vss cim_bitcell
Xcell_r54_c6 bl6 blb6 wl54 wwl54 q_r54c6 qb_r54c6 vdd vss cim_bitcell
Xcell_r54_c7 bl7 blb7 wl54 wwl54 q_r54c7 qb_r54c7 vdd vss cim_bitcell
Xcell_r55_c0 bl0 blb0 wl55 wwl55 q_r55c0 qb_r55c0 vdd vss cim_bitcell
Xcell_r55_c1 bl1 blb1 wl55 wwl55 q_r55c1 qb_r55c1 vdd vss cim_bitcell
Xcell_r55_c2 bl2 blb2 wl55 wwl55 q_r55c2 qb_r55c2 vdd vss cim_bitcell
Xcell_r55_c3 bl3 blb3 wl55 wwl55 q_r55c3 qb_r55c3 vdd vss cim_bitcell
Xcell_r55_c4 bl4 blb4 wl55 wwl55 q_r55c4 qb_r55c4 vdd vss cim_bitcell
Xcell_r55_c5 bl5 blb5 wl55 wwl55 q_r55c5 qb_r55c5 vdd vss cim_bitcell
Xcell_r55_c6 bl6 blb6 wl55 wwl55 q_r55c6 qb_r55c6 vdd vss cim_bitcell
Xcell_r55_c7 bl7 blb7 wl55 wwl55 q_r55c7 qb_r55c7 vdd vss cim_bitcell
Xcell_r56_c0 bl0 blb0 wl56 wwl56 q_r56c0 qb_r56c0 vdd vss cim_bitcell
Xcell_r56_c1 bl1 blb1 wl56 wwl56 q_r56c1 qb_r56c1 vdd vss cim_bitcell
Xcell_r56_c2 bl2 blb2 wl56 wwl56 q_r56c2 qb_r56c2 vdd vss cim_bitcell
Xcell_r56_c3 bl3 blb3 wl56 wwl56 q_r56c3 qb_r56c3 vdd vss cim_bitcell
Xcell_r56_c4 bl4 blb4 wl56 wwl56 q_r56c4 qb_r56c4 vdd vss cim_bitcell
Xcell_r56_c5 bl5 blb5 wl56 wwl56 q_r56c5 qb_r56c5 vdd vss cim_bitcell
Xcell_r56_c6 bl6 blb6 wl56 wwl56 q_r56c6 qb_r56c6 vdd vss cim_bitcell
Xcell_r56_c7 bl7 blb7 wl56 wwl56 q_r56c7 qb_r56c7 vdd vss cim_bitcell
Xcell_r57_c0 bl0 blb0 wl57 wwl57 q_r57c0 qb_r57c0 vdd vss cim_bitcell
Xcell_r57_c1 bl1 blb1 wl57 wwl57 q_r57c1 qb_r57c1 vdd vss cim_bitcell
Xcell_r57_c2 bl2 blb2 wl57 wwl57 q_r57c2 qb_r57c2 vdd vss cim_bitcell
Xcell_r57_c3 bl3 blb3 wl57 wwl57 q_r57c3 qb_r57c3 vdd vss cim_bitcell
Xcell_r57_c4 bl4 blb4 wl57 wwl57 q_r57c4 qb_r57c4 vdd vss cim_bitcell
Xcell_r57_c5 bl5 blb5 wl57 wwl57 q_r57c5 qb_r57c5 vdd vss cim_bitcell
Xcell_r57_c6 bl6 blb6 wl57 wwl57 q_r57c6 qb_r57c6 vdd vss cim_bitcell
Xcell_r57_c7 bl7 blb7 wl57 wwl57 q_r57c7 qb_r57c7 vdd vss cim_bitcell
Xcell_r58_c0 bl0 blb0 wl58 wwl58 q_r58c0 qb_r58c0 vdd vss cim_bitcell
Xcell_r58_c1 bl1 blb1 wl58 wwl58 q_r58c1 qb_r58c1 vdd vss cim_bitcell
Xcell_r58_c2 bl2 blb2 wl58 wwl58 q_r58c2 qb_r58c2 vdd vss cim_bitcell
Xcell_r58_c3 bl3 blb3 wl58 wwl58 q_r58c3 qb_r58c3 vdd vss cim_bitcell
Xcell_r58_c4 bl4 blb4 wl58 wwl58 q_r58c4 qb_r58c4 vdd vss cim_bitcell
Xcell_r58_c5 bl5 blb5 wl58 wwl58 q_r58c5 qb_r58c5 vdd vss cim_bitcell
Xcell_r58_c6 bl6 blb6 wl58 wwl58 q_r58c6 qb_r58c6 vdd vss cim_bitcell
Xcell_r58_c7 bl7 blb7 wl58 wwl58 q_r58c7 qb_r58c7 vdd vss cim_bitcell
Xcell_r59_c0 bl0 blb0 wl59 wwl59 q_r59c0 qb_r59c0 vdd vss cim_bitcell
Xcell_r59_c1 bl1 blb1 wl59 wwl59 q_r59c1 qb_r59c1 vdd vss cim_bitcell
Xcell_r59_c2 bl2 blb2 wl59 wwl59 q_r59c2 qb_r59c2 vdd vss cim_bitcell
Xcell_r59_c3 bl3 blb3 wl59 wwl59 q_r59c3 qb_r59c3 vdd vss cim_bitcell
Xcell_r59_c4 bl4 blb4 wl59 wwl59 q_r59c4 qb_r59c4 vdd vss cim_bitcell
Xcell_r59_c5 bl5 blb5 wl59 wwl59 q_r59c5 qb_r59c5 vdd vss cim_bitcell
Xcell_r59_c6 bl6 blb6 wl59 wwl59 q_r59c6 qb_r59c6 vdd vss cim_bitcell
Xcell_r59_c7 bl7 blb7 wl59 wwl59 q_r59c7 qb_r59c7 vdd vss cim_bitcell
Xcell_r60_c0 bl0 blb0 wl60 wwl60 q_r60c0 qb_r60c0 vdd vss cim_bitcell
Xcell_r60_c1 bl1 blb1 wl60 wwl60 q_r60c1 qb_r60c1 vdd vss cim_bitcell
Xcell_r60_c2 bl2 blb2 wl60 wwl60 q_r60c2 qb_r60c2 vdd vss cim_bitcell
Xcell_r60_c3 bl3 blb3 wl60 wwl60 q_r60c3 qb_r60c3 vdd vss cim_bitcell
Xcell_r60_c4 bl4 blb4 wl60 wwl60 q_r60c4 qb_r60c4 vdd vss cim_bitcell
Xcell_r60_c5 bl5 blb5 wl60 wwl60 q_r60c5 qb_r60c5 vdd vss cim_bitcell
Xcell_r60_c6 bl6 blb6 wl60 wwl60 q_r60c6 qb_r60c6 vdd vss cim_bitcell
Xcell_r60_c7 bl7 blb7 wl60 wwl60 q_r60c7 qb_r60c7 vdd vss cim_bitcell
Xcell_r61_c0 bl0 blb0 wl61 wwl61 q_r61c0 qb_r61c0 vdd vss cim_bitcell
Xcell_r61_c1 bl1 blb1 wl61 wwl61 q_r61c1 qb_r61c1 vdd vss cim_bitcell
Xcell_r61_c2 bl2 blb2 wl61 wwl61 q_r61c2 qb_r61c2 vdd vss cim_bitcell
Xcell_r61_c3 bl3 blb3 wl61 wwl61 q_r61c3 qb_r61c3 vdd vss cim_bitcell
Xcell_r61_c4 bl4 blb4 wl61 wwl61 q_r61c4 qb_r61c4 vdd vss cim_bitcell
Xcell_r61_c5 bl5 blb5 wl61 wwl61 q_r61c5 qb_r61c5 vdd vss cim_bitcell
Xcell_r61_c6 bl6 blb6 wl61 wwl61 q_r61c6 qb_r61c6 vdd vss cim_bitcell
Xcell_r61_c7 bl7 blb7 wl61 wwl61 q_r61c7 qb_r61c7 vdd vss cim_bitcell
Xcell_r62_c0 bl0 blb0 wl62 wwl62 q_r62c0 qb_r62c0 vdd vss cim_bitcell
Xcell_r62_c1 bl1 blb1 wl62 wwl62 q_r62c1 qb_r62c1 vdd vss cim_bitcell
Xcell_r62_c2 bl2 blb2 wl62 wwl62 q_r62c2 qb_r62c2 vdd vss cim_bitcell
Xcell_r62_c3 bl3 blb3 wl62 wwl62 q_r62c3 qb_r62c3 vdd vss cim_bitcell
Xcell_r62_c4 bl4 blb4 wl62 wwl62 q_r62c4 qb_r62c4 vdd vss cim_bitcell
Xcell_r62_c5 bl5 blb5 wl62 wwl62 q_r62c5 qb_r62c5 vdd vss cim_bitcell
Xcell_r62_c6 bl6 blb6 wl62 wwl62 q_r62c6 qb_r62c6 vdd vss cim_bitcell
Xcell_r62_c7 bl7 blb7 wl62 wwl62 q_r62c7 qb_r62c7 vdd vss cim_bitcell
Xcell_r63_c0 bl0 blb0 wl63 wwl63 q_r63c0 qb_r63c0 vdd vss cim_bitcell
Xcell_r63_c1 bl1 blb1 wl63 wwl63 q_r63c1 qb_r63c1 vdd vss cim_bitcell
Xcell_r63_c2 bl2 blb2 wl63 wwl63 q_r63c2 qb_r63c2 vdd vss cim_bitcell
Xcell_r63_c3 bl3 blb3 wl63 wwl63 q_r63c3 qb_r63c3 vdd vss cim_bitcell
Xcell_r63_c4 bl4 blb4 wl63 wwl63 q_r63c4 qb_r63c4 vdd vss cim_bitcell
Xcell_r63_c5 bl5 blb5 wl63 wwl63 q_r63c5 qb_r63c5 vdd vss cim_bitcell
Xcell_r63_c6 bl6 blb6 wl63 wwl63 q_r63c6 qb_r63c6 vdd vss cim_bitcell
Xcell_r63_c7 bl7 blb7 wl63 wwl63 q_r63c7 qb_r63c7 vdd vss cim_bitcell

* Initial conditions
.ic v(bl0)=1.8
.ic v(bl1)=1.8
.ic v(bl2)=1.8
.ic v(bl3)=1.8
.ic v(bl4)=1.8
.ic v(bl5)=1.8
.ic v(bl6)=1.8
.ic v(bl7)=1.8
.ic v(q_r0c0)=0 v(qb_r0c0)=1.8
.ic v(q_r0c1)=0 v(qb_r0c1)=1.8
.ic v(q_r0c2)=0 v(qb_r0c2)=1.8
.ic v(q_r0c3)=1.8 v(qb_r0c3)=0
.ic v(q_r0c4)=1.8 v(qb_r0c4)=0
.ic v(q_r0c5)=1.8 v(qb_r0c5)=0
.ic v(q_r0c6)=1.8 v(qb_r0c6)=0
.ic v(q_r0c7)=0 v(qb_r0c7)=1.8
.ic v(q_r1c0)=0 v(qb_r1c0)=1.8
.ic v(q_r1c1)=1.8 v(qb_r1c1)=0
.ic v(q_r1c2)=0 v(qb_r1c2)=1.8
.ic v(q_r1c3)=0 v(qb_r1c3)=1.8
.ic v(q_r1c4)=1.8 v(qb_r1c4)=0
.ic v(q_r1c5)=1.8 v(qb_r1c5)=0
.ic v(q_r1c6)=1.8 v(qb_r1c6)=0
.ic v(q_r1c7)=1.8 v(qb_r1c7)=0
.ic v(q_r2c0)=0 v(qb_r2c0)=1.8
.ic v(q_r2c1)=1.8 v(qb_r2c1)=0
.ic v(q_r2c2)=1.8 v(qb_r2c2)=0
.ic v(q_r2c3)=0 v(qb_r2c3)=1.8
.ic v(q_r2c4)=1.8 v(qb_r2c4)=0
.ic v(q_r2c5)=0 v(qb_r2c5)=1.8
.ic v(q_r2c6)=1.8 v(qb_r2c6)=0
.ic v(q_r2c7)=1.8 v(qb_r2c7)=0
.ic v(q_r3c0)=0 v(qb_r3c0)=1.8
.ic v(q_r3c1)=1.8 v(qb_r3c1)=0
.ic v(q_r3c2)=1.8 v(qb_r3c2)=0
.ic v(q_r3c3)=0 v(qb_r3c3)=1.8
.ic v(q_r3c4)=1.8 v(qb_r3c4)=0
.ic v(q_r3c5)=1.8 v(qb_r3c5)=0
.ic v(q_r3c6)=0 v(qb_r3c6)=1.8
.ic v(q_r3c7)=0 v(qb_r3c7)=1.8
.ic v(q_r4c0)=0 v(qb_r4c0)=1.8
.ic v(q_r4c1)=1.8 v(qb_r4c1)=0
.ic v(q_r4c2)=1.8 v(qb_r4c2)=0
.ic v(q_r4c3)=1.8 v(qb_r4c3)=0
.ic v(q_r4c4)=0 v(qb_r4c4)=1.8
.ic v(q_r4c5)=1.8 v(qb_r4c5)=0
.ic v(q_r4c6)=0 v(qb_r4c6)=1.8
.ic v(q_r4c7)=0 v(qb_r4c7)=1.8
.ic v(q_r5c0)=1.8 v(qb_r5c0)=0
.ic v(q_r5c1)=0 v(qb_r5c1)=1.8
.ic v(q_r5c2)=1.8 v(qb_r5c2)=0
.ic v(q_r5c3)=1.8 v(qb_r5c3)=0
.ic v(q_r5c4)=1.8 v(qb_r5c4)=0
.ic v(q_r5c5)=1.8 v(qb_r5c5)=0
.ic v(q_r5c6)=0 v(qb_r5c6)=1.8
.ic v(q_r5c7)=0 v(qb_r5c7)=1.8
.ic v(q_r6c0)=1.8 v(qb_r6c0)=0
.ic v(q_r6c1)=0 v(qb_r6c1)=1.8
.ic v(q_r6c2)=1.8 v(qb_r6c2)=0
.ic v(q_r6c3)=1.8 v(qb_r6c3)=0
.ic v(q_r6c4)=1.8 v(qb_r6c4)=0
.ic v(q_r6c5)=1.8 v(qb_r6c5)=0
.ic v(q_r6c6)=0 v(qb_r6c6)=1.8
.ic v(q_r6c7)=0 v(qb_r6c7)=1.8
.ic v(q_r7c0)=0 v(qb_r7c0)=1.8
.ic v(q_r7c1)=0 v(qb_r7c1)=1.8
.ic v(q_r7c2)=0 v(qb_r7c2)=1.8
.ic v(q_r7c3)=1.8 v(qb_r7c3)=0
.ic v(q_r7c4)=0 v(qb_r7c4)=1.8
.ic v(q_r7c5)=1.8 v(qb_r7c5)=0
.ic v(q_r7c6)=1.8 v(qb_r7c6)=0
.ic v(q_r7c7)=1.8 v(qb_r7c7)=0
.ic v(q_r8c0)=1.8 v(qb_r8c0)=0
.ic v(q_r8c1)=1.8 v(qb_r8c1)=0
.ic v(q_r8c2)=0 v(qb_r8c2)=1.8
.ic v(q_r8c3)=1.8 v(qb_r8c3)=0
.ic v(q_r8c4)=0 v(qb_r8c4)=1.8
.ic v(q_r8c5)=0 v(qb_r8c5)=1.8
.ic v(q_r8c6)=1.8 v(qb_r8c6)=0
.ic v(q_r8c7)=0 v(qb_r8c7)=1.8
.ic v(q_r9c0)=0 v(qb_r9c0)=1.8
.ic v(q_r9c1)=1.8 v(qb_r9c1)=0
.ic v(q_r9c2)=1.8 v(qb_r9c2)=0
.ic v(q_r9c3)=0 v(qb_r9c3)=1.8
.ic v(q_r9c4)=0 v(qb_r9c4)=1.8
.ic v(q_r9c5)=0 v(qb_r9c5)=1.8
.ic v(q_r9c6)=1.8 v(qb_r9c6)=0
.ic v(q_r9c7)=1.8 v(qb_r9c7)=0
.ic v(q_r10c0)=0 v(qb_r10c0)=1.8
.ic v(q_r10c1)=0 v(qb_r10c1)=1.8
.ic v(q_r10c2)=1.8 v(qb_r10c2)=0
.ic v(q_r10c3)=1.8 v(qb_r10c3)=0
.ic v(q_r10c4)=1.8 v(qb_r10c4)=0
.ic v(q_r10c5)=1.8 v(qb_r10c5)=0
.ic v(q_r10c6)=0 v(qb_r10c6)=1.8
.ic v(q_r10c7)=1.8 v(qb_r10c7)=0
.ic v(q_r11c0)=0 v(qb_r11c0)=1.8
.ic v(q_r11c1)=1.8 v(qb_r11c1)=0
.ic v(q_r11c2)=1.8 v(qb_r11c2)=0
.ic v(q_r11c3)=0 v(qb_r11c3)=1.8
.ic v(q_r11c4)=1.8 v(qb_r11c4)=0
.ic v(q_r11c5)=1.8 v(qb_r11c5)=0
.ic v(q_r11c6)=1.8 v(qb_r11c6)=0
.ic v(q_r11c7)=1.8 v(qb_r11c7)=0
.ic v(q_r12c0)=0 v(qb_r12c0)=1.8
.ic v(q_r12c1)=0 v(qb_r12c1)=1.8
.ic v(q_r12c2)=1.8 v(qb_r12c2)=0
.ic v(q_r12c3)=1.8 v(qb_r12c3)=0
.ic v(q_r12c4)=0 v(qb_r12c4)=1.8
.ic v(q_r12c5)=0 v(qb_r12c5)=1.8
.ic v(q_r12c6)=0 v(qb_r12c6)=1.8
.ic v(q_r12c7)=0 v(qb_r12c7)=1.8
.ic v(q_r13c0)=0 v(qb_r13c0)=1.8
.ic v(q_r13c1)=1.8 v(qb_r13c1)=0
.ic v(q_r13c2)=0 v(qb_r13c2)=1.8
.ic v(q_r13c3)=0 v(qb_r13c3)=1.8
.ic v(q_r13c4)=1.8 v(qb_r13c4)=0
.ic v(q_r13c5)=1.8 v(qb_r13c5)=0
.ic v(q_r13c6)=1.8 v(qb_r13c6)=0
.ic v(q_r13c7)=1.8 v(qb_r13c7)=0
.ic v(q_r14c0)=0 v(qb_r14c0)=1.8
.ic v(q_r14c1)=0 v(qb_r14c1)=1.8
.ic v(q_r14c2)=1.8 v(qb_r14c2)=0
.ic v(q_r14c3)=0 v(qb_r14c3)=1.8
.ic v(q_r14c4)=0 v(qb_r14c4)=1.8
.ic v(q_r14c5)=1.8 v(qb_r14c5)=0
.ic v(q_r14c6)=1.8 v(qb_r14c6)=0
.ic v(q_r14c7)=1.8 v(qb_r14c7)=0
.ic v(q_r15c0)=1.8 v(qb_r15c0)=0
.ic v(q_r15c1)=0 v(qb_r15c1)=1.8
.ic v(q_r15c2)=1.8 v(qb_r15c2)=0
.ic v(q_r15c3)=0 v(qb_r15c3)=1.8
.ic v(q_r15c4)=1.8 v(qb_r15c4)=0
.ic v(q_r15c5)=1.8 v(qb_r15c5)=0
.ic v(q_r15c6)=0 v(qb_r15c6)=1.8
.ic v(q_r15c7)=1.8 v(qb_r15c7)=0
.ic v(q_r16c0)=0 v(qb_r16c0)=1.8
.ic v(q_r16c1)=1.8 v(qb_r16c1)=0
.ic v(q_r16c2)=0 v(qb_r16c2)=1.8
.ic v(q_r16c3)=0 v(qb_r16c3)=1.8
.ic v(q_r16c4)=0 v(qb_r16c4)=1.8
.ic v(q_r16c5)=0 v(qb_r16c5)=1.8
.ic v(q_r16c6)=0 v(qb_r16c6)=1.8
.ic v(q_r16c7)=0 v(qb_r16c7)=1.8
.ic v(q_r17c0)=0 v(qb_r17c0)=1.8
.ic v(q_r17c1)=1.8 v(qb_r17c1)=0
.ic v(q_r17c2)=0 v(qb_r17c2)=1.8
.ic v(q_r17c3)=0 v(qb_r17c3)=1.8
.ic v(q_r17c4)=0 v(qb_r17c4)=1.8
.ic v(q_r17c5)=1.8 v(qb_r17c5)=0
.ic v(q_r17c6)=0 v(qb_r17c6)=1.8
.ic v(q_r17c7)=0 v(qb_r17c7)=1.8
.ic v(q_r18c0)=1.8 v(qb_r18c0)=0
.ic v(q_r18c1)=0 v(qb_r18c1)=1.8
.ic v(q_r18c2)=0 v(qb_r18c2)=1.8
.ic v(q_r18c3)=0 v(qb_r18c3)=1.8
.ic v(q_r18c4)=1.8 v(qb_r18c4)=0
.ic v(q_r18c5)=1.8 v(qb_r18c5)=0
.ic v(q_r18c6)=0 v(qb_r18c6)=1.8
.ic v(q_r18c7)=1.8 v(qb_r18c7)=0
.ic v(q_r19c0)=0 v(qb_r19c0)=1.8
.ic v(q_r19c1)=0 v(qb_r19c1)=1.8
.ic v(q_r19c2)=1.8 v(qb_r19c2)=0
.ic v(q_r19c3)=0 v(qb_r19c3)=1.8
.ic v(q_r19c4)=1.8 v(qb_r19c4)=0
.ic v(q_r19c5)=0 v(qb_r19c5)=1.8
.ic v(q_r19c6)=1.8 v(qb_r19c6)=0
.ic v(q_r19c7)=0 v(qb_r19c7)=1.8
.ic v(q_r20c0)=0 v(qb_r20c0)=1.8
.ic v(q_r20c1)=1.8 v(qb_r20c1)=0
.ic v(q_r20c2)=0 v(qb_r20c2)=1.8
.ic v(q_r20c3)=1.8 v(qb_r20c3)=0
.ic v(q_r20c4)=0 v(qb_r20c4)=1.8
.ic v(q_r20c5)=1.8 v(qb_r20c5)=0
.ic v(q_r20c6)=0 v(qb_r20c6)=1.8
.ic v(q_r20c7)=1.8 v(qb_r20c7)=0
.ic v(q_r21c0)=0 v(qb_r21c0)=1.8
.ic v(q_r21c1)=0 v(qb_r21c1)=1.8
.ic v(q_r21c2)=1.8 v(qb_r21c2)=0
.ic v(q_r21c3)=1.8 v(qb_r21c3)=0
.ic v(q_r21c4)=0 v(qb_r21c4)=1.8
.ic v(q_r21c5)=0 v(qb_r21c5)=1.8
.ic v(q_r21c6)=1.8 v(qb_r21c6)=0
.ic v(q_r21c7)=0 v(qb_r21c7)=1.8
.ic v(q_r22c0)=0 v(qb_r22c0)=1.8
.ic v(q_r22c1)=1.8 v(qb_r22c1)=0
.ic v(q_r22c2)=0 v(qb_r22c2)=1.8
.ic v(q_r22c3)=0 v(qb_r22c3)=1.8
.ic v(q_r22c4)=0 v(qb_r22c4)=1.8
.ic v(q_r22c5)=1.8 v(qb_r22c5)=0
.ic v(q_r22c6)=1.8 v(qb_r22c6)=0
.ic v(q_r22c7)=1.8 v(qb_r22c7)=0
.ic v(q_r23c0)=0 v(qb_r23c0)=1.8
.ic v(q_r23c1)=1.8 v(qb_r23c1)=0
.ic v(q_r23c2)=1.8 v(qb_r23c2)=0
.ic v(q_r23c3)=0 v(qb_r23c3)=1.8
.ic v(q_r23c4)=1.8 v(qb_r23c4)=0
.ic v(q_r23c5)=1.8 v(qb_r23c5)=0
.ic v(q_r23c6)=0 v(qb_r23c6)=1.8
.ic v(q_r23c7)=0 v(qb_r23c7)=1.8
.ic v(q_r24c0)=0 v(qb_r24c0)=1.8
.ic v(q_r24c1)=1.8 v(qb_r24c1)=0
.ic v(q_r24c2)=1.8 v(qb_r24c2)=0
.ic v(q_r24c3)=1.8 v(qb_r24c3)=0
.ic v(q_r24c4)=1.8 v(qb_r24c4)=0
.ic v(q_r24c5)=1.8 v(qb_r24c5)=0
.ic v(q_r24c6)=1.8 v(qb_r24c6)=0
.ic v(q_r24c7)=0 v(qb_r24c7)=1.8
.ic v(q_r25c0)=0 v(qb_r25c0)=1.8
.ic v(q_r25c1)=0 v(qb_r25c1)=1.8
.ic v(q_r25c2)=0 v(qb_r25c2)=1.8
.ic v(q_r25c3)=1.8 v(qb_r25c3)=0
.ic v(q_r25c4)=0 v(qb_r25c4)=1.8
.ic v(q_r25c5)=0 v(qb_r25c5)=1.8
.ic v(q_r25c6)=0 v(qb_r25c6)=1.8
.ic v(q_r25c7)=1.8 v(qb_r25c7)=0
.ic v(q_r26c0)=0 v(qb_r26c0)=1.8
.ic v(q_r26c1)=1.8 v(qb_r26c1)=0
.ic v(q_r26c2)=0 v(qb_r26c2)=1.8
.ic v(q_r26c3)=0 v(qb_r26c3)=1.8
.ic v(q_r26c4)=0 v(qb_r26c4)=1.8
.ic v(q_r26c5)=1.8 v(qb_r26c5)=0
.ic v(q_r26c6)=0 v(qb_r26c6)=1.8
.ic v(q_r26c7)=1.8 v(qb_r26c7)=0
.ic v(q_r27c0)=0 v(qb_r27c0)=1.8
.ic v(q_r27c1)=0 v(qb_r27c1)=1.8
.ic v(q_r27c2)=0 v(qb_r27c2)=1.8
.ic v(q_r27c3)=0 v(qb_r27c3)=1.8
.ic v(q_r27c4)=0 v(qb_r27c4)=1.8
.ic v(q_r27c5)=1.8 v(qb_r27c5)=0
.ic v(q_r27c6)=1.8 v(qb_r27c6)=0
.ic v(q_r27c7)=0 v(qb_r27c7)=1.8
.ic v(q_r28c0)=1.8 v(qb_r28c0)=0
.ic v(q_r28c1)=1.8 v(qb_r28c1)=0
.ic v(q_r28c2)=1.8 v(qb_r28c2)=0
.ic v(q_r28c3)=0 v(qb_r28c3)=1.8
.ic v(q_r28c4)=1.8 v(qb_r28c4)=0
.ic v(q_r28c5)=1.8 v(qb_r28c5)=0
.ic v(q_r28c6)=1.8 v(qb_r28c6)=0
.ic v(q_r28c7)=0 v(qb_r28c7)=1.8
.ic v(q_r29c0)=1.8 v(qb_r29c0)=0
.ic v(q_r29c1)=1.8 v(qb_r29c1)=0
.ic v(q_r29c2)=1.8 v(qb_r29c2)=0
.ic v(q_r29c3)=0 v(qb_r29c3)=1.8
.ic v(q_r29c4)=0 v(qb_r29c4)=1.8
.ic v(q_r29c5)=0 v(qb_r29c5)=1.8
.ic v(q_r29c6)=1.8 v(qb_r29c6)=0
.ic v(q_r29c7)=0 v(qb_r29c7)=1.8
.ic v(q_r30c0)=0 v(qb_r30c0)=1.8
.ic v(q_r30c1)=1.8 v(qb_r30c1)=0
.ic v(q_r30c2)=0 v(qb_r30c2)=1.8
.ic v(q_r30c3)=0 v(qb_r30c3)=1.8
.ic v(q_r30c4)=0 v(qb_r30c4)=1.8
.ic v(q_r30c5)=1.8 v(qb_r30c5)=0
.ic v(q_r30c6)=1.8 v(qb_r30c6)=0
.ic v(q_r30c7)=1.8 v(qb_r30c7)=0
.ic v(q_r31c0)=0 v(qb_r31c0)=1.8
.ic v(q_r31c1)=1.8 v(qb_r31c1)=0
.ic v(q_r31c2)=0 v(qb_r31c2)=1.8
.ic v(q_r31c3)=1.8 v(qb_r31c3)=0
.ic v(q_r31c4)=1.8 v(qb_r31c4)=0
.ic v(q_r31c5)=0 v(qb_r31c5)=1.8
.ic v(q_r31c6)=1.8 v(qb_r31c6)=0
.ic v(q_r31c7)=1.8 v(qb_r31c7)=0
.ic v(q_r32c0)=1.8 v(qb_r32c0)=0
.ic v(q_r32c1)=0 v(qb_r32c1)=1.8
.ic v(q_r32c2)=1.8 v(qb_r32c2)=0
.ic v(q_r32c3)=0 v(qb_r32c3)=1.8
.ic v(q_r32c4)=1.8 v(qb_r32c4)=0
.ic v(q_r32c5)=1.8 v(qb_r32c5)=0
.ic v(q_r32c6)=1.8 v(qb_r32c6)=0
.ic v(q_r32c7)=1.8 v(qb_r32c7)=0
.ic v(q_r33c0)=0 v(qb_r33c0)=1.8
.ic v(q_r33c1)=0 v(qb_r33c1)=1.8
.ic v(q_r33c2)=1.8 v(qb_r33c2)=0
.ic v(q_r33c3)=0 v(qb_r33c3)=1.8
.ic v(q_r33c4)=0 v(qb_r33c4)=1.8
.ic v(q_r33c5)=1.8 v(qb_r33c5)=0
.ic v(q_r33c6)=0 v(qb_r33c6)=1.8
.ic v(q_r33c7)=1.8 v(qb_r33c7)=0
.ic v(q_r34c0)=0 v(qb_r34c0)=1.8
.ic v(q_r34c1)=0 v(qb_r34c1)=1.8
.ic v(q_r34c2)=1.8 v(qb_r34c2)=0
.ic v(q_r34c3)=0 v(qb_r34c3)=1.8
.ic v(q_r34c4)=0 v(qb_r34c4)=1.8
.ic v(q_r34c5)=0 v(qb_r34c5)=1.8
.ic v(q_r34c6)=1.8 v(qb_r34c6)=0
.ic v(q_r34c7)=1.8 v(qb_r34c7)=0
.ic v(q_r35c0)=0 v(qb_r35c0)=1.8
.ic v(q_r35c1)=1.8 v(qb_r35c1)=0
.ic v(q_r35c2)=0 v(qb_r35c2)=1.8
.ic v(q_r35c3)=1.8 v(qb_r35c3)=0
.ic v(q_r35c4)=0 v(qb_r35c4)=1.8
.ic v(q_r35c5)=0 v(qb_r35c5)=1.8
.ic v(q_r35c6)=1.8 v(qb_r35c6)=0
.ic v(q_r35c7)=0 v(qb_r35c7)=1.8
.ic v(q_r36c0)=0 v(qb_r36c0)=1.8
.ic v(q_r36c1)=0 v(qb_r36c1)=1.8
.ic v(q_r36c2)=1.8 v(qb_r36c2)=0
.ic v(q_r36c3)=1.8 v(qb_r36c3)=0
.ic v(q_r36c4)=0 v(qb_r36c4)=1.8
.ic v(q_r36c5)=0 v(qb_r36c5)=1.8
.ic v(q_r36c6)=1.8 v(qb_r36c6)=0
.ic v(q_r36c7)=0 v(qb_r36c7)=1.8
.ic v(q_r37c0)=0 v(qb_r37c0)=1.8
.ic v(q_r37c1)=1.8 v(qb_r37c1)=0
.ic v(q_r37c2)=0 v(qb_r37c2)=1.8
.ic v(q_r37c3)=0 v(qb_r37c3)=1.8
.ic v(q_r37c4)=1.8 v(qb_r37c4)=0
.ic v(q_r37c5)=0 v(qb_r37c5)=1.8
.ic v(q_r37c6)=0 v(qb_r37c6)=1.8
.ic v(q_r37c7)=0 v(qb_r37c7)=1.8
.ic v(q_r38c0)=0 v(qb_r38c0)=1.8
.ic v(q_r38c1)=0 v(qb_r38c1)=1.8
.ic v(q_r38c2)=0 v(qb_r38c2)=1.8
.ic v(q_r38c3)=1.8 v(qb_r38c3)=0
.ic v(q_r38c4)=0 v(qb_r38c4)=1.8
.ic v(q_r38c5)=1.8 v(qb_r38c5)=0
.ic v(q_r38c6)=0 v(qb_r38c6)=1.8
.ic v(q_r38c7)=1.8 v(qb_r38c7)=0
.ic v(q_r39c0)=0 v(qb_r39c0)=1.8
.ic v(q_r39c1)=1.8 v(qb_r39c1)=0
.ic v(q_r39c2)=0 v(qb_r39c2)=1.8
.ic v(q_r39c3)=0 v(qb_r39c3)=1.8
.ic v(q_r39c4)=1.8 v(qb_r39c4)=0
.ic v(q_r39c5)=1.8 v(qb_r39c5)=0
.ic v(q_r39c6)=1.8 v(qb_r39c6)=0
.ic v(q_r39c7)=0 v(qb_r39c7)=1.8
.ic v(q_r40c0)=1.8 v(qb_r40c0)=0
.ic v(q_r40c1)=0 v(qb_r40c1)=1.8
.ic v(q_r40c2)=0 v(qb_r40c2)=1.8
.ic v(q_r40c3)=0 v(qb_r40c3)=1.8
.ic v(q_r40c4)=1.8 v(qb_r40c4)=0
.ic v(q_r40c5)=1.8 v(qb_r40c5)=0
.ic v(q_r40c6)=0 v(qb_r40c6)=1.8
.ic v(q_r40c7)=1.8 v(qb_r40c7)=0
.ic v(q_r41c0)=1.8 v(qb_r41c0)=0
.ic v(q_r41c1)=1.8 v(qb_r41c1)=0
.ic v(q_r41c2)=1.8 v(qb_r41c2)=0
.ic v(q_r41c3)=0 v(qb_r41c3)=1.8
.ic v(q_r41c4)=0 v(qb_r41c4)=1.8
.ic v(q_r41c5)=1.8 v(qb_r41c5)=0
.ic v(q_r41c6)=1.8 v(qb_r41c6)=0
.ic v(q_r41c7)=0 v(qb_r41c7)=1.8
.ic v(q_r42c0)=1.8 v(qb_r42c0)=0
.ic v(q_r42c1)=1.8 v(qb_r42c1)=0
.ic v(q_r42c2)=1.8 v(qb_r42c2)=0
.ic v(q_r42c3)=0 v(qb_r42c3)=1.8
.ic v(q_r42c4)=1.8 v(qb_r42c4)=0
.ic v(q_r42c5)=1.8 v(qb_r42c5)=0
.ic v(q_r42c6)=1.8 v(qb_r42c6)=0
.ic v(q_r42c7)=0 v(qb_r42c7)=1.8
.ic v(q_r43c0)=0 v(qb_r43c0)=1.8
.ic v(q_r43c1)=0 v(qb_r43c1)=1.8
.ic v(q_r43c2)=0 v(qb_r43c2)=1.8
.ic v(q_r43c3)=0 v(qb_r43c3)=1.8
.ic v(q_r43c4)=0 v(qb_r43c4)=1.8
.ic v(q_r43c5)=1.8 v(qb_r43c5)=0
.ic v(q_r43c6)=1.8 v(qb_r43c6)=0
.ic v(q_r43c7)=0 v(qb_r43c7)=1.8
.ic v(q_r44c0)=0 v(qb_r44c0)=1.8
.ic v(q_r44c1)=0 v(qb_r44c1)=1.8
.ic v(q_r44c2)=1.8 v(qb_r44c2)=0
.ic v(q_r44c3)=0 v(qb_r44c3)=1.8
.ic v(q_r44c4)=0 v(qb_r44c4)=1.8
.ic v(q_r44c5)=0 v(qb_r44c5)=1.8
.ic v(q_r44c6)=0 v(qb_r44c6)=1.8
.ic v(q_r44c7)=0 v(qb_r44c7)=1.8
.ic v(q_r45c0)=0 v(qb_r45c0)=1.8
.ic v(q_r45c1)=1.8 v(qb_r45c1)=0
.ic v(q_r45c2)=1.8 v(qb_r45c2)=0
.ic v(q_r45c3)=1.8 v(qb_r45c3)=0
.ic v(q_r45c4)=1.8 v(qb_r45c4)=0
.ic v(q_r45c5)=1.8 v(qb_r45c5)=0
.ic v(q_r45c6)=0 v(qb_r45c6)=1.8
.ic v(q_r45c7)=1.8 v(qb_r45c7)=0
.ic v(q_r46c0)=0 v(qb_r46c0)=1.8
.ic v(q_r46c1)=0 v(qb_r46c1)=1.8
.ic v(q_r46c2)=0 v(qb_r46c2)=1.8
.ic v(q_r46c3)=0 v(qb_r46c3)=1.8
.ic v(q_r46c4)=0 v(qb_r46c4)=1.8
.ic v(q_r46c5)=0 v(qb_r46c5)=1.8
.ic v(q_r46c6)=0 v(qb_r46c6)=1.8
.ic v(q_r46c7)=1.8 v(qb_r46c7)=0
.ic v(q_r47c0)=1.8 v(qb_r47c0)=0
.ic v(q_r47c1)=0 v(qb_r47c1)=1.8
.ic v(q_r47c2)=1.8 v(qb_r47c2)=0
.ic v(q_r47c3)=0 v(qb_r47c3)=1.8
.ic v(q_r47c4)=1.8 v(qb_r47c4)=0
.ic v(q_r47c5)=0 v(qb_r47c5)=1.8
.ic v(q_r47c6)=1.8 v(qb_r47c6)=0
.ic v(q_r47c7)=1.8 v(qb_r47c7)=0
.ic v(q_r48c0)=1.8 v(qb_r48c0)=0
.ic v(q_r48c1)=0 v(qb_r48c1)=1.8
.ic v(q_r48c2)=0 v(qb_r48c2)=1.8
.ic v(q_r48c3)=1.8 v(qb_r48c3)=0
.ic v(q_r48c4)=1.8 v(qb_r48c4)=0
.ic v(q_r48c5)=1.8 v(qb_r48c5)=0
.ic v(q_r48c6)=1.8 v(qb_r48c6)=0
.ic v(q_r48c7)=1.8 v(qb_r48c7)=0
.ic v(q_r49c0)=0 v(qb_r49c0)=1.8
.ic v(q_r49c1)=0 v(qb_r49c1)=1.8
.ic v(q_r49c2)=0 v(qb_r49c2)=1.8
.ic v(q_r49c3)=1.8 v(qb_r49c3)=0
.ic v(q_r49c4)=0 v(qb_r49c4)=1.8
.ic v(q_r49c5)=1.8 v(qb_r49c5)=0
.ic v(q_r49c6)=1.8 v(qb_r49c6)=0
.ic v(q_r49c7)=1.8 v(qb_r49c7)=0
.ic v(q_r50c0)=0 v(qb_r50c0)=1.8
.ic v(q_r50c1)=1.8 v(qb_r50c1)=0
.ic v(q_r50c2)=1.8 v(qb_r50c2)=0
.ic v(q_r50c3)=1.8 v(qb_r50c3)=0
.ic v(q_r50c4)=1.8 v(qb_r50c4)=0
.ic v(q_r50c5)=1.8 v(qb_r50c5)=0
.ic v(q_r50c6)=1.8 v(qb_r50c6)=0
.ic v(q_r50c7)=1.8 v(qb_r50c7)=0
.ic v(q_r51c0)=0 v(qb_r51c0)=1.8
.ic v(q_r51c1)=1.8 v(qb_r51c1)=0
.ic v(q_r51c2)=1.8 v(qb_r51c2)=0
.ic v(q_r51c3)=1.8 v(qb_r51c3)=0
.ic v(q_r51c4)=0 v(qb_r51c4)=1.8
.ic v(q_r51c5)=1.8 v(qb_r51c5)=0
.ic v(q_r51c6)=1.8 v(qb_r51c6)=0
.ic v(q_r51c7)=0 v(qb_r51c7)=1.8
.ic v(q_r52c0)=0 v(qb_r52c0)=1.8
.ic v(q_r52c1)=1.8 v(qb_r52c1)=0
.ic v(q_r52c2)=0 v(qb_r52c2)=1.8
.ic v(q_r52c3)=0 v(qb_r52c3)=1.8
.ic v(q_r52c4)=1.8 v(qb_r52c4)=0
.ic v(q_r52c5)=0 v(qb_r52c5)=1.8
.ic v(q_r52c6)=0 v(qb_r52c6)=1.8
.ic v(q_r52c7)=0 v(qb_r52c7)=1.8
.ic v(q_r53c0)=0 v(qb_r53c0)=1.8
.ic v(q_r53c1)=1.8 v(qb_r53c1)=0
.ic v(q_r53c2)=1.8 v(qb_r53c2)=0
.ic v(q_r53c3)=1.8 v(qb_r53c3)=0
.ic v(q_r53c4)=1.8 v(qb_r53c4)=0
.ic v(q_r53c5)=1.8 v(qb_r53c5)=0
.ic v(q_r53c6)=0 v(qb_r53c6)=1.8
.ic v(q_r53c7)=1.8 v(qb_r53c7)=0
.ic v(q_r54c0)=0 v(qb_r54c0)=1.8
.ic v(q_r54c1)=1.8 v(qb_r54c1)=0
.ic v(q_r54c2)=1.8 v(qb_r54c2)=0
.ic v(q_r54c3)=1.8 v(qb_r54c3)=0
.ic v(q_r54c4)=1.8 v(qb_r54c4)=0
.ic v(q_r54c5)=1.8 v(qb_r54c5)=0
.ic v(q_r54c6)=0 v(qb_r54c6)=1.8
.ic v(q_r54c7)=0 v(qb_r54c7)=1.8
.ic v(q_r55c0)=1.8 v(qb_r55c0)=0
.ic v(q_r55c1)=1.8 v(qb_r55c1)=0
.ic v(q_r55c2)=1.8 v(qb_r55c2)=0
.ic v(q_r55c3)=1.8 v(qb_r55c3)=0
.ic v(q_r55c4)=0 v(qb_r55c4)=1.8
.ic v(q_r55c5)=0 v(qb_r55c5)=1.8
.ic v(q_r55c6)=1.8 v(qb_r55c6)=0
.ic v(q_r55c7)=1.8 v(qb_r55c7)=0
.ic v(q_r56c0)=0 v(qb_r56c0)=1.8
.ic v(q_r56c1)=0 v(qb_r56c1)=1.8
.ic v(q_r56c2)=1.8 v(qb_r56c2)=0
.ic v(q_r56c3)=0 v(qb_r56c3)=1.8
.ic v(q_r56c4)=1.8 v(qb_r56c4)=0
.ic v(q_r56c5)=1.8 v(qb_r56c5)=0
.ic v(q_r56c6)=0 v(qb_r56c6)=1.8
.ic v(q_r56c7)=1.8 v(qb_r56c7)=0
.ic v(q_r57c0)=1.8 v(qb_r57c0)=0
.ic v(q_r57c1)=1.8 v(qb_r57c1)=0
.ic v(q_r57c2)=1.8 v(qb_r57c2)=0
.ic v(q_r57c3)=1.8 v(qb_r57c3)=0
.ic v(q_r57c4)=1.8 v(qb_r57c4)=0
.ic v(q_r57c5)=1.8 v(qb_r57c5)=0
.ic v(q_r57c6)=1.8 v(qb_r57c6)=0
.ic v(q_r57c7)=0 v(qb_r57c7)=1.8
.ic v(q_r58c0)=0 v(qb_r58c0)=1.8
.ic v(q_r58c1)=1.8 v(qb_r58c1)=0
.ic v(q_r58c2)=0 v(qb_r58c2)=1.8
.ic v(q_r58c3)=1.8 v(qb_r58c3)=0
.ic v(q_r58c4)=0 v(qb_r58c4)=1.8
.ic v(q_r58c5)=0 v(qb_r58c5)=1.8
.ic v(q_r58c6)=0 v(qb_r58c6)=1.8
.ic v(q_r58c7)=1.8 v(qb_r58c7)=0
.ic v(q_r59c0)=1.8 v(qb_r59c0)=0
.ic v(q_r59c1)=0 v(qb_r59c1)=1.8
.ic v(q_r59c2)=0 v(qb_r59c2)=1.8
.ic v(q_r59c3)=1.8 v(qb_r59c3)=0
.ic v(q_r59c4)=0 v(qb_r59c4)=1.8
.ic v(q_r59c5)=0 v(qb_r59c5)=1.8
.ic v(q_r59c6)=1.8 v(qb_r59c6)=0
.ic v(q_r59c7)=0 v(qb_r59c7)=1.8
.ic v(q_r60c0)=1.8 v(qb_r60c0)=0
.ic v(q_r60c1)=0 v(qb_r60c1)=1.8
.ic v(q_r60c2)=1.8 v(qb_r60c2)=0
.ic v(q_r60c3)=1.8 v(qb_r60c3)=0
.ic v(q_r60c4)=1.8 v(qb_r60c4)=0
.ic v(q_r60c5)=0 v(qb_r60c5)=1.8
.ic v(q_r60c6)=0 v(qb_r60c6)=1.8
.ic v(q_r60c7)=0 v(qb_r60c7)=1.8
.ic v(q_r61c0)=0 v(qb_r61c0)=1.8
.ic v(q_r61c1)=1.8 v(qb_r61c1)=0
.ic v(q_r61c2)=0 v(qb_r61c2)=1.8
.ic v(q_r61c3)=0 v(qb_r61c3)=1.8
.ic v(q_r61c4)=0 v(qb_r61c4)=1.8
.ic v(q_r61c5)=0 v(qb_r61c5)=1.8
.ic v(q_r61c6)=0 v(qb_r61c6)=1.8
.ic v(q_r61c7)=1.8 v(qb_r61c7)=0
.ic v(q_r62c0)=0 v(qb_r62c0)=1.8
.ic v(q_r62c1)=1.8 v(qb_r62c1)=0
.ic v(q_r62c2)=0 v(qb_r62c2)=1.8
.ic v(q_r62c3)=0 v(qb_r62c3)=1.8
.ic v(q_r62c4)=1.8 v(qb_r62c4)=0
.ic v(q_r62c5)=1.8 v(qb_r62c5)=0
.ic v(q_r62c6)=1.8 v(qb_r62c6)=0
.ic v(q_r62c7)=1.8 v(qb_r62c7)=0
.ic v(q_r63c0)=0 v(qb_r63c0)=1.8
.ic v(q_r63c1)=0 v(qb_r63c1)=1.8
.ic v(q_r63c2)=0 v(qb_r63c2)=1.8
.ic v(q_r63c3)=1.8 v(qb_r63c3)=0
.ic v(q_r63c4)=1.8 v(qb_r63c4)=0
.ic v(q_r63c5)=0 v(qb_r63c5)=1.8
.ic v(q_r63c6)=1.8 v(qb_r63c6)=0
.ic v(q_r63c7)=0 v(qb_r63c7)=1.8

.tran 0.05n 120.97n UIC

.meas tran vbl0 FIND v(bl0) AT=110.97n
.meas tran vbl1 FIND v(bl1) AT=110.97n
.meas tran vbl2 FIND v(bl2) AT=110.97n
.meas tran vbl3 FIND v(bl3) AT=110.97n
.meas tran vbl4 FIND v(bl4) AT=110.97n
.meas tran vbl5 FIND v(bl5) AT=110.97n
.meas tran vbl6 FIND v(bl6) AT=110.97n
.meas tran vbl7 FIND v(bl7) AT=110.97n

.meas tran compute_done WHEN v(wl0)=0 FALL=1

.meas tran avg_idd AVG i(Vdd) FROM=0n TO=115.97n

.save v(bl0) v(bl1) v(bl2) v(bl3) v(bl4) v(bl5) v(bl6) v(bl7) v(wl0) v(wl1) v(wl2) v(wl3) v(wl4) v(wl5) v(wl6) v(wl7) v(wl8) v(wl9) v(wl10) v(wl11) v(wl12) v(wl13) v(wl14) v(wl15) v(wl16) v(wl17) v(wl18) v(wl19) v(wl20) v(wl21) v(wl22) v(wl23) v(wl24) v(wl25) v(wl26) v(wl27) v(wl28) v(wl29) v(wl30) v(wl31) v(wl32) v(wl33) v(wl34) v(wl35) v(wl36) v(wl37) v(wl38) v(wl39) v(wl40) v(wl41) v(wl42) v(wl43) v(wl44) v(wl45) v(wl46) v(wl47) v(wl48) v(wl49) v(wl50) v(wl51) v(wl52) v(wl53) v(wl54) v(wl55) v(wl56) v(wl57) v(wl58) v(wl59) v(wl60) v(wl61) v(wl62) v(wl63) v(pre)

.control
run
wrdata array_output.txt v(bl0) v(bl1) v(bl2) v(bl3) v(bl4) v(bl5) v(bl6) v(bl7)
.endc

.end
