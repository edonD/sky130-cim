* PWM Wordline Driver for CIM
* Converts 4-bit input code to proportional pulse width on wordline
*
* Architecture:
*   1. Behavioral pulse generator (PWL source, models digital counter + comparator)
*   2. 3-inverter buffer chain to drive wordline load
*
* The PWL input is INVERTED (high during idle, low during pulse) because
* the odd number of inverters provides one net inversion.
*
* Parameters set by evaluate.py via .param line substitution
* Wbuf, Lbuf, Wlogic are in micrometers (u suffix in .param)

.lib "sky130_models/sky130.lib.spice" tt
.param supply=1.8
.param Wbuf=4.0u Lbuf=0.15u Nstages=3 Tlsb=5.0n Wlogic=1.0u

* ============================================================
* Power supply
* ============================================================
Vdd vdd 0 {supply}
Vss vss 0 0

* ============================================================
* Clock — 3MHz (period = 333.3ns)
* ============================================================
Vclk clk 0 PULSE(0 {supply} 0 0.1n 0.1n 166.55n 333.3n)

* ============================================================
* 4-bit input code (DC levels)
* These are set by evaluate.py build_netlist
* ============================================================
Vin0 in0 0 1.8
Vin1 in1 0 0
Vin2 in2 0 1.8
Vin3 in3 0 1.8

* ============================================================
* PWM pulse generator (PWL source, generated by evaluate.py)
* NOTE: Signal is INVERTED — high=idle, low=active pulse
* The 3-inverter chain produces a non-inverted output
* ============================================================
Vpwm pwm_in 0 PWL(0.1n 1.8 0.2n 0 65.1n 0 65.19999999999999n 1.8 333.40000000000003n 1.8 333.50000000000006n 0 398.40000000000003n 0 398.50000000000006n 1.8)

* ============================================================
* 3-Inverter Buffer Chain (6 transistors total)
* Progressive sizing: 1x -> 2x -> 4x tapering
* Odd inversions: inverted input -> non-inverted output
* ============================================================

* --- Inverter 1: W_n=Wlogic, W_p=2*Wlogic ---
XMn1 n1 pwm_in vss vss sky130_fd_pr__nfet_01v8 W={Wlogic} L={Lbuf}
XMp1 n1 pwm_in vdd vdd sky130_fd_pr__pfet_01v8 W={2*Wlogic} L={Lbuf}

* --- Inverter 2: W_n=Wbuf/2, W_p=Wbuf ---
XMn2 n2 n1 vss vss sky130_fd_pr__nfet_01v8 W={Wbuf/2} L={Lbuf}
XMp2 n2 n1 vdd vdd sky130_fd_pr__pfet_01v8 W={Wbuf} L={Lbuf}

* --- Inverter 3 (output): W_n=Wbuf, W_p=2*Wbuf ---
XMn3 wl n2 vss vss sky130_fd_pr__nfet_01v8 W={Wbuf} L={Lbuf}
XMp3 wl n2 vdd vdd sky130_fd_pr__pfet_01v8 W={2*Wbuf} L={Lbuf}

* ============================================================
* Wordline load: 100fF (64 bitcell gates)
* ============================================================
Cload wl 0 100f

* ============================================================
* Simulation control
* ============================================================
.temp 27
.control
tran 0.1n 700n
meas tran pw_rise TRIG v(wl) val=0.9 rise=1 TARG v(wl) val=0.9 fall=1
meas tran t_rise TRIG v(wl) val=0.18 rise=1 TARG v(wl) val=1.62 rise=1
meas tran t_fall TRIG v(wl) val=1.62 fall=1 TARG v(wl) val=0.18 fall=1
meas tran avg_power AVG i(Vdd) from=0 to=333.3n
let power_uw = -avg_power * 1.8 * 1e6
print pw_rise t_rise t_fall power_uw
wrdata pwm_waveform_code13.dat v(wl) v(pwm_in) v(clk)
.endc

.end
