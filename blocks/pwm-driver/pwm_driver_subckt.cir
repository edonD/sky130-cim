* PWM Wordline Driver Subcircuit for CIM Integration
* SKY130 130nm, 1.8V supply
*
* Port order per interfaces.md:
*   .subckt pwm_driver in3 in2 in1 in0 wl clk vdd vss
*
* Architecture: 3-inverter CMOS buffer chain (6 transistors)
* Performance: tr=0.148ns, tf=0.097ns, power=1.321uW, linearity=0.026%

.subckt pwm_driver in3 in2 in1 in0 wl clk vdd vss

* Digital logic generates pwm_in (active-low) from in3..in0 and clk.

* --- Inverter 1: W_n=1.0u, W_p=2.0u ---
XMn1 n1 pwm_in vss vss sky130_fd_pr__nfet_01v8 W=1.0u L=0.15u
XMp1 n1 pwm_in vdd vdd sky130_fd_pr__pfet_01v8 W=2.0u L=0.15u

* --- Inverter 2: W_n=2.0u, W_p=4.0u ---
XMn2 n2 n1 vss vss sky130_fd_pr__nfet_01v8 W=2.0u L=0.15u
XMp2 n2 n1 vdd vdd sky130_fd_pr__pfet_01v8 W=4.0u L=0.15u

* --- Inverter 3 (output): W_n=4.0u, W_p=8.0u ---
XMn3 wl n2 vss vss sky130_fd_pr__nfet_01v8 W=4.0u L=0.15u
XMp3 wl n2 vdd vdd sky130_fd_pr__pfet_01v8 W=8.0u L=0.15u

.ends pwm_driver
