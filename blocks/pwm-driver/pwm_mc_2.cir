* PWM Wordline Driver for CIM
* Converts 4-bit input code to proportional pulse width on wordline
*
* Architecture:
*   1. Behavioral pulse generator (PWL source, models digital counter + comparator)
*   2. Transistor-level buffer chain to drive wordline load
*
* Parameters set by evaluate.py via .param line substitution
* Wbuf, Lbuf, Wlogic are in micrometers (u suffix in .param)

.lib "sky130_models/sky130.lib.spice" tt
.param supply=1.8
.param Wbuf=4.631685126202957u Lbuf=0.15u Nstages=3 Tlsb=5.0n Wlogic=1.076743472915291u

* ============================================================
* Power supply
* ============================================================
Vdd vdd 0 {supply}
Vss vss 0 0

* ============================================================
* Clock — 3MHz (period = 333.3ns)
* ============================================================
Vclk clk 0 PULSE(0 {supply} 0 0.1n 0.1n 166.55n 333.3n)

* ============================================================
* 4-bit input code (DC levels)
* These are set by evaluate.py build_netlist
* ============================================================
Vin0 in0 0 1.8
Vin1 in1 0 1.8
Vin2 in2 0 1.8
Vin3 in3 0 0

* ============================================================
* PWM pulse generator (PWL source, generated by evaluate.py)
* Produces pulse of width = input_code * Tlsb at each clock edge
* ============================================================
Vpwm pwm_clean 0 PWL(0.1n 0 0.2n 1.8 35.1n 1.8 35.2n 0 333.40000000000003n 0 333.50000000000006n 1.8 368.40000000000003n 1.8 368.50000000000006n 0)

* ============================================================
* Transistor-level output buffer chain
* Progressive sizing: each stage is ~3x the previous
* Stage 1 uses Wlogic, subsequent stages scale up to Wbuf
* ============================================================

* --- Buffer Stage 1 ---
* Inverter 1a (first inversion)
XMn1a buf_int1 pwm_clean vss vss sky130_fd_pr__nfet_01v8 W={Wlogic} L={Lbuf}
XMp1a buf_int1 pwm_clean vdd vdd sky130_fd_pr__pfet_01v8 W={2*Wlogic} L={Lbuf}

* Inverter 1b (restore polarity)
XMn1b buf_out1 buf_int1 vss vss sky130_fd_pr__nfet_01v8 W={Wlogic} L={Lbuf}
XMp1b buf_out1 buf_int1 vdd vdd sky130_fd_pr__pfet_01v8 W={2*Wlogic} L={Lbuf}

* --- Buffer Stage 2 (if Nstages >= 2) ---
.if (Nstages >= 2)
XMn2a buf_int2 buf_out1 vss vss sky130_fd_pr__nfet_01v8 W={Wbuf/3} L={Lbuf}
XMp2a buf_int2 buf_out1 vdd vdd sky130_fd_pr__pfet_01v8 W={2*Wbuf/3} L={Lbuf}
XMn2b buf_out2 buf_int2 vss vss sky130_fd_pr__nfet_01v8 W={Wbuf/3} L={Lbuf}
XMp2b buf_out2 buf_int2 vdd vdd sky130_fd_pr__pfet_01v8 W={2*Wbuf/3} L={Lbuf}
.endif

* --- Buffer Stage 3 (if Nstages >= 3) ---
.if (Nstages >= 3)
XMn3a buf_int3 buf_out2 vss vss sky130_fd_pr__nfet_01v8 W={Wbuf} L={Lbuf}
XMp3a buf_int3 buf_out2 vdd vdd sky130_fd_pr__pfet_01v8 W={2*Wbuf} L={Lbuf}
XMn3b buf_out3 buf_int3 vss vss sky130_fd_pr__nfet_01v8 W={Wbuf} L={Lbuf}
XMp3b buf_out3 buf_int3 vdd vdd sky130_fd_pr__pfet_01v8 W={2*Wbuf} L={Lbuf}
.endif

* --- Buffer Stage 4 (if Nstages >= 4) ---
.if (Nstages >= 4)
XMn4a buf_int4 buf_out3 vss vss sky130_fd_pr__nfet_01v8 W={3*Wbuf} L={Lbuf}
XMp4a buf_int4 buf_out3 vdd vdd sky130_fd_pr__pfet_01v8 W={6*Wbuf} L={Lbuf}
XMn4b buf_out4 buf_int4 vss vss sky130_fd_pr__nfet_01v8 W={3*Wbuf} L={Lbuf}
XMp4b buf_out4 buf_int4 vdd vdd sky130_fd_pr__pfet_01v8 W={6*Wbuf} L={Lbuf}
.endif

* ============================================================
* Output node selection based on Nstages
* ============================================================
.if (Nstages == 1)
Rwl_sel buf_out1 wl 0.01
.elseif (Nstages == 2)
Rwl_sel buf_out2 wl 0.01
.elseif (Nstages == 3)
Rwl_sel buf_out3 wl 0.01
.elseif (Nstages == 4)
Rwl_sel buf_out4 wl 0.01
.endif

* ============================================================
* Wordline load: 100fF (64 bitcell gates)
* ============================================================
Cload wl 0 100f

* ============================================================
* Simulation control
* ============================================================
.temp 27
.control
tran 0.1n 700n
meas tran pw_rise TRIG v(wl) val=0.9 rise=1 TARG v(wl) val=0.9 fall=1
meas tran t_rise TRIG v(wl) val=0.18 rise=1 TARG v(wl) val=1.62 rise=1
meas tran t_fall TRIG v(wl) val=1.62 fall=1 TARG v(wl) val=0.18 fall=1
meas tran avg_power AVG i(Vdd) from=0 to=333.3n
let power_uw = -avg_power * 1.8 * 1e6
print pw_rise t_rise t_fall power_uw
wrdata pwm_results.txt v(wl) v(pwm_clean) v(clk)
.endc

.end
